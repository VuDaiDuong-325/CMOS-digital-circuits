*Custom Compiler Version N-2017.12-SP1-2
*Wed Mar 18 23:30:56 2026

.GLOBAL 0 gnd! vdd!
********************************************************************************
* Library          : dff
* Cell             : dff
* View             : starrc
* View Search List : schematic hspice symbol
* View Stop List   : symbol
********************************************************************************
.subckt dff
r742 597:clkb 599:clkb  r=8.55001
r741 592:clkb 608:clkb  r=0.05
r740 592:clkb 593:clkb  r=0.05
r739 591:clkb 594:clkb  r=0.0933333
r738 591:clkb 592:clkb  r=2
r737 589:clkb 607:clkb  r=0.05
r736 589:clkb 590:clkb  r=0.05
r735 588:clkb 610:clkb  r=0.05
r734 588:clkb 589:clkb  r=2
r733 586:clkb 613:clkb  r=0.0508666
r732 586:clkb 603:clkb  r=0.05
r731 585:clkb 588:clkb  r=1.04667
r730 585:clkb 586:clkb  r=2
r729 582:clkb 606:clkb  r=0.05
r728 582:clkb 583:clkb  r=0.05
r727 581:clkb 585:clkb  r=0.6
r726 581:clkb 584:clkb  r=0.05
r725 581:clkb 582:clkb  r=2
r724 578:clkb 604:clkb  r=0.05
r723 578:clkb 579:clkb  r=0.05
r722 577:clkb 605:clkb  r=0.0793333
r721 577:clkb 580:clkb  r=0.116667
r720 577:clkb 578:clkb  r=2
r719 575:clkb 576:clkb  r=0.119
r718 573:clkb 574:clkb  r=0.266
r717 572:clkb 614:clkb  r=0.119
r716 572:clkb 573:clkb  r=0.266
r715 571:clkb 612:clkb  r=0.0411765
r714 571:clkb 603:clkb  r=0.407647
r713 570:clkb 611:clkb  r=0.0411765
r712 570:clkb 606:clkb  r=0.411765
r711 567:clkb 569:clkb  r=0.0411765
r710 566:clkb 574:clkb  r=2.863
r709 566:clkb 575:clkb  r=0.35
r708 565:clkb 608:clkb  r=0.265517
r707 565:clkb 566:clkb  r=0.378
r706 564:clkb 587:clkb  r=0.05
r705 563:clkb 564:clkb  r=0.05
r704 563:clkb 607:clkb  r=0.470256
r703 562:clkb 604:clkb  r=0.395652
r702 562:clkb 567:clkb  r=0.0411765
r701 560:clkb 596:clkb  r=8.55001
r700 559:clkb 598:clkb  r=8.55001
r699 558:clkb 595:clkb  r=8.55001
r698 557:clkb 609:clkb  r=0.0933333
r697 557:clkb 577:clkb  r=4.85333
r696 557:clkb 561:clkb  r=0.116667
r695 557:clkb 564:clkb  r=2
r694 557:clkb 591:clkb  r=0.874054
r693 xi15|mm3|drn 575:clkb  r=18
r692 xi15|mm2|drn 574:clkb  r=18
r691 xi15|mm2|drn 573:clkb  r=18
r690 xi15|mm2|drn 572:clkb  r=18
r689 556:clkb clkb  r=11.7
r688 xi16|mm1|gate 596:clkb  r=16.2
r687 xi16|mm1|gate 556:clkb  r=16.2
r686 555:clkb 602:clkb  r=11.7
r685 xi17|mm0|gate 598:clkb  r=32.4
r684 xi17|mm0|gate 555:clkb  r=32.4
r683 554:clkb 601:clkb  r=11.7
r682 xi19|mm0|gate 595:clkb  r=32.4
r681 xi19|mm0|gate 554:clkb  r=32.4
r680 553:clkb 600:clkb  r=11.7
r679 xi18|mm1|gate 597:clkb  r=16.2
r678 xi18|mm1|gate 553:clkb  r=16.2
r677 552:clkb 560:clkb  r=32.4
r676 551:clkb 565:clkb  r=18
r675 551:clkb 552:clkb  r=3.71739
r674 550:clkb 551:clkb  r=3.71739
r673 549:clkb 559:clkb  r=31.95
r672 548:clkb 571:clkb  r=18
r671 548:clkb 549:clkb  r=3.71739
r670 547:clkb 548:clkb  r=3.71739
r669 546:clkb 558:clkb  r=32.4
r668 545:clkb 570:clkb  r=18
r667 545:clkb 546:clkb  r=3.71739
r666 544:clkb 545:clkb  r=3.71739
r665 543:clkb 599:clkb  r=37.35
r664 542:clkb 568:clkb  r=5.44737
r663 542:clkb 567:clkb  r=18
r662 542:clkb 543:clkb  r=3.07895
r661 d 541:d  r=0.119
r660 540:d d  r=3.199
r659 539:d 540:d  r=0.266
r658 537:d 539:d  r=0.266
r657 537:d 538:d  r=0.119
r656 xi16|mm1|drn d  r=18
r655 xi16|mm0|drn 540:d  r=18
r654 xi16|mm0|drn 539:d  r=18
r653 xi16|mm0|drn 537:d  r=18
r652 527:clk 535:clk  r=0.178182
r651 525:clk 532:clk  r=0.179375
r650 514:clk 536:clk  r=0.05
r649 514:clk 515:clk  r=0.05
r648 513:clk 529:clk  r=0.084
r647 513:clk 514:clk  r=2
r646 511:clk 535:clk  r=0.05
r645 511:clk 512:clk  r=0.05
r644 510:clk 511:clk  r=2
r643 507:clk 528:clk  r=0.05
r642 507:clk 508:clk  r=0.05
r641 506:clk 513:clk  r=0.628205
r640 506:clk 509:clk  r=0.084
r639 506:clk 507:clk  r=2
r638 503:clk 533:clk  r=0.05
r637 503:clk 504:clk  r=0.05
r636 502:clk 503:clk  r=2
r635 501:clk 534:clk  r=0.0793333
r634 499:clk 523:clk  r=0.05
r633 499:clk 500:clk  r=0.05
r632 498:clk 505:clk  r=0.0793333
r631 498:clk 501:clk  r=0.6265
r630 498:clk 499:clk  r=2
r629 496:clk 531:clk  r=0.0793333
r628 496:clk 502:clk  r=2.43667
r627 492:clk 494:clk  r=3.6383
r626 492:clk 493:clk  r=3.6383
r625 491:clk 495:clk  r=0.0411765
r624 491:clk 492:clk  r=18
r623 489:clk 527:clk  r=0.0411765
r622 487:clk 532:clk  r=0.0411765
r621 487:clk 488:clk  r=0.0411765
r620 485:clk 486:clk  r=0.0411765
r619 483:clk 530:clk  r=0.0411765
r618 483:clk 484:clk  r=0.0411765
r617 482:clk 528:clk  r=0.186667
r616 482:clk 489:clk  r=0.0411765
r615 481:clk 525:clk  r=0.05
r614 481:clk 501:clk  r=2
r613 480:clk 485:clk  r=0.0411765
r612 480:clk 523:clk  r=0.231538
r611 479:clk 497:clk  r=0.05
r610 479:clk 496:clk  r=2
r609 478:clk 502:clk  r=0.05
r608 478:clk 510:clk  r=1.80976
r607 476:clk 520:clk  r=69.7501
r606 476:clk 494:clk  r=15.8294
r605 475:clk 476:clk  r=99.0001
r604 474:clk 491:clk  r=0.0411765
r603 474:clk 536:clk  r=0.161212
r602 xi15|mm3|gate 475:clk  r=16.2
r601 473:clk 477:clk  r=11.7
r600 473:clk xi15|mm3|gate  r=16.2
r599 472:clk 518:clk  r=65.2501
r598 471:clk 519:clk  r=8.55001
r597 470:clk 517:clk  r=8.55001
r596 469:clk 516:clk  r=8.55001
r595 468:clk clk  r=11.7
r594 xi15|mm2|gate 520:clk  r=32.4
r593 xi15|mm2|gate 468:clk  r=32.4
r592 467:clk 526:clk  r=11.7
r591 xi16|mm0|gate 518:clk  r=32.4
r590 xi16|mm0|gate 467:clk  r=32.4
r589 466:clk 524:clk  r=11.7
r588 xi17|mm1|gate 519:clk  r=16.2
r587 xi17|mm1|gate 466:clk  r=16.2
r586 465:clk 522:clk  r=11.7
r585 xi19|mm1|gate 517:clk  r=16.2
r584 xi19|mm1|gate 465:clk  r=16.2
r583 464:clk 521:clk  r=11.7
r582 xi18|mm0|gate 516:clk  r=32.4
r581 xi18|mm0|gate 464:clk  r=32.4
r580 463:clk 533:clk  r=0.196875
r579 463:clk 481:clk  r=0.05
r578 462:clk 530:clk  r=0.742424
r577 462:clk 479:clk  r=0.05
r576 461:clk 490:clk  r=3.7174
r575 461:clk 489:clk  r=18
r574 460:clk 472:clk  r=18.2727
r573 460:clk 461:clk  r=3.7174
r572 459:clk 471:clk  r=33.3
r571 458:clk 487:clk  r=18
r570 458:clk 459:clk  r=3.7174
r569 457:clk 458:clk  r=3.7174
r568 456:clk 470:clk  r=32.4
r567 455:clk 485:clk  r=18
r566 455:clk 456:clk  r=3.71739
r565 454:clk 455:clk  r=3.71739
r564 453:clk 469:clk  r=32.4
r563 452:clk 483:clk  r=18
r562 452:clk 453:clk  r=3.71739
r561 451:clk 452:clk  r=3.71739
r560 439:vdd! 450:vdd!  r=0.05
r559 439:vdd! 449:vdd!  r=0.05
r558 438:vdd! 440:vdd!  r=0.098
r557 438:vdd! 439:vdd!  r=2
r556 437:vdd! 450:vdd!  r=0.294
r555 436:vdd! 437:vdd!  r=0.05
r554 432:vdd! 434:vdd!  r=0.05
r553 432:vdd! 433:vdd!  r=0.05
r552 431:vdd! 438:vdd!  r=0.0746666
r551 431:vdd! 436:vdd!  r=2
r550 431:vdd! 435:vdd!  r=0.0516577
r549 431:vdd! 432:vdd!  r=2
r548 427:vdd! 448:vdd!  r=0.294
r547 426:vdd! 427:vdd!  r=0.05
r546 425:vdd! 448:vdd!  r=0.05
r545 425:vdd! 445:vdd!  r=0.05
r544 422:vdd! 424:vdd!  r=0.05
r543 422:vdd! 423:vdd!  r=0.05
r542 421:vdd! 431:vdd!  r=0.26877
r541 421:vdd! 428:vdd!  r=0.112
r540 421:vdd! 426:vdd!  r=2
r539 421:vdd! 425:vdd!  r=2
r538 421:vdd! 422:vdd!  r=2
r537 420:vdd! 447:vdd!  r=0.294
r536 419:vdd! 420:vdd!  r=0.05
r535 418:vdd! 447:vdd!  r=0.05
r534 418:vdd! 446:vdd!  r=0.05
r533 415:vdd! 417:vdd!  r=0.05
r532 415:vdd! 416:vdd!  r=0.05
r531 414:vdd! 430:vdd!  r=0.112
r530 414:vdd! 421:vdd!  r=0.137754
r529 414:vdd! 419:vdd!  r=2
r528 414:vdd! 418:vdd!  r=2
r527 414:vdd! 415:vdd!  r=2
r526 411:vdd! 444:vdd!  r=0.05
r525 411:vdd! 441:vdd!  r=0.05
r524 410:vdd! 413:vdd!  r=0.05
r523 410:vdd! 412:vdd!  r=0.05
r522 409:vdd! 444:vdd!  r=0.294
r521 408:vdd! 429:vdd!  r=0.158667
r520 408:vdd! 411:vdd!  r=2
r519 408:vdd! 410:vdd!  r=2
r518 407:vdd! 443:vdd!  r=0.308
r517 404:vdd! 406:vdd!  r=0.05
r516 404:vdd! 405:vdd!  r=0.05
r515 403:vdd! 407:vdd!  r=0.05
r514 400:vdd! 443:vdd!  r=0.05
r513 400:vdd! 442:vdd!  r=0.05
r512 399:vdd! 408:vdd!  r=0.135508
r511 399:vdd! 404:vdd!  r=2
r510 399:vdd! 403:vdd!  r=2
r509 399:vdd! 402:vdd!  r=0.144667
r508 399:vdd! 401:vdd!  r=0.241069
r507 399:vdd! 400:vdd!  r=2
r506 397:vdd! 398:vdd!  r=0.119
r505 396:vdd! 397:vdd!  r=0.266
r504 395:vdd! 449:vdd!  r=0.84
r503 395:vdd! 396:vdd!  r=0.266
r502 393:vdd! 394:vdd!  r=0.119
r501 392:vdd! 393:vdd!  r=0.266
r500 391:vdd! 445:vdd!  r=0.931
r499 391:vdd! 392:vdd!  r=0.266
r498 389:vdd! 390:vdd!  r=0.119
r497 388:vdd! 389:vdd!  r=0.266
r496 387:vdd! 446:vdd!  r=0.931
r495 387:vdd! 388:vdd!  r=0.266
r494 385:vdd! 386:vdd!  r=0.119
r493 384:vdd! 385:vdd!  r=0.266
r492 382:vdd! 383:vdd!  r=0.119
r491 381:vdd! 382:vdd!  r=0.266
r490 380:vdd! 442:vdd!  r=0.882
r489 380:vdd! 381:vdd!  r=0.266
r488 379:vdd! 409:vdd!  r=0.05
r487 379:vdd! 408:vdd!  r=2
r486 378:vdd! 441:vdd!  r=0.7987
r485 378:vdd! 384:vdd!  r=0.30968
r484 377:vdd! 405:vdd!  r=0.308
r483 377:vdd! 403:vdd!  r=0.05
r482 vdd! 408:vdd!  r=0.183018
r481 vdd! 414:vdd!  r=0.172866
r480 xi15|mm2|src 397:vdd!  r=18
r479 xi15|mm2|src 396:vdd!  r=18
r478 xi15|mm2|src 395:vdd!  r=18
r477 xi20|mm2|src 393:vdd!  r=18
r476 xi20|mm2|src 392:vdd!  r=18
r475 xi20|mm2|src 391:vdd!  r=18
r474 xi21|mm2|src 389:vdd!  r=18
r473 xi21|mm2|src 388:vdd!  r=18
r472 xi21|mm2|src 387:vdd!  r=18
r471 xi23|mm2|src 385:vdd!  r=18
r470 xi23|mm2|src 384:vdd!  r=18
r469 xi23|mm2|src 378:vdd!  r=18
r468 xi22|mm2|src 382:vdd!  r=18
r467 xi22|mm2|src 381:vdd!  r=18
r466 xi22|mm2|src 380:vdd!  r=18
r465 376:vdd! 412:vdd!  r=0.294
r464 376:vdd! 379:vdd!  r=0.05
r463 375:vdd! 436:vdd!  r=0.05
r462 375:vdd! 433:vdd!  r=0.301
r461 374:vdd! 426:vdd!  r=0.05
r460 374:vdd! 423:vdd!  r=0.294
r459 373:vdd! 419:vdd!  r=0.05
r458 373:vdd! 416:vdd!  r=0.294
r457 xi18|mm1|bulk xi23|mm3|bulk  r=0.001
r456 xi18|mm1|bulk xi17|mm1|bulk  r=0.001
r455 xi18|mm1|bulk xi19|mm1|bulk  r=0.001
r454 xi18|mm1|bulk xi21|mm3|bulk  r=0.001
r453 xi18|mm1|bulk xi20|mm3|bulk  r=0.001
r452 xi18|mm1|bulk xi16|mm1|bulk  r=0.001
r451 xi18|mm1|bulk xi15|mm3|bulk  r=0.001
r450 ln_n_140 xi18|mm1|bulk  r=0.001
r449 ln_n_140 xi22|mm3|bulk  r=0.001
r448 ln_n_183 371:ln_n_183  r=7.2766
r447 369:ln_n_183 372:ln_n_183  r=143.1
r446 369:ln_n_183 370:ln_n_183  r=146.25
r445 369:ln_n_183 ln_n_183  r=15.8294
r444 362:net75 367:net75  r=0.098
r443 362:net75 363:net75  r=0.098
r442 361:net75 362:net75  r=2
r441 359:net75 365:net75  r=0.098
r440 359:net75 364:net75  r=0.098
r439 358:net75 361:net75  r=1.21
r438 358:net75 360:net75  r=0.084
r437 358:net75 359:net75  r=2
r436 356:net75 357:net75  r=0.119
r435 354:net75 355:net75  r=0.266
r434 353:net75 366:net75  r=0.119
r433 352:net75 353:net75  r=3.164
r432 351:net75 352:net75  r=0.266
r431 350:net75 364:net75  r=0.168965
r430 350:net75 351:net75  r=0.23254
r429 349:net75 368:net75  r=0.119
r428 348:net75 354:net75  r=0.231
r427 348:net75 363:net75  r=0.173793
r426 347:net75 349:net75  r=0.378
r425 347:net75 355:net75  r=0.385
r424 347:net75 356:net75  r=2.807
r423 345:net75 346:net75  r=11.7
r422 xi19|mm1|src 356:net75  r=18
r421 xi19|mm0|src 355:net75  r=18
r420 xi19|mm0|src 354:net75  r=18
r419 xi19|mm0|src 348:net75  r=18
r418 xi18|mm1|drn 353:net75  r=18
r417 xi18|mm0|drn 350:net75  r=18
r416 xi18|mm0|drn 351:net75  r=18
r415 xi18|mm0|drn 352:net75  r=18
r414 xi23|mm3|gate 345:net75  r=16.2
r413 343:net75 xi23|mm3|gate  r=16.2
r412 342:net75 net75  r=11.7
r411 xi23|mm2|gate 344:net75  r=32.4
r410 xi23|mm2|gate 342:net75  r=32.4
r409 341:net75 344:net75  r=8.55001
r408 341:net75 343:net75  r=163.35
r407 340:net75 341:net75  r=33.3
r406 339:net75 349:net75  r=18
r405 339:net75 340:net75  r=3.7174
r404 338:net75 339:net75  r=3.7174
r403 337:net75 361:net75  r=0.05
r402 334:ln_n_193 335:ln_n_193  r=7.43479
r401 333:ln_n_193 336:ln_n_193  r=207
r400 333:ln_n_193 334:ln_n_193  r=31.95
r399 333:ln_n_193 ln_n_193  r=85.0501
r398 330:ln_n_187 331:ln_n_187  r=7.43479
r397 329:ln_n_187 332:ln_n_187  r=181.35
r396 329:ln_n_187 330:ln_n_187  r=19.4897
r395 329:ln_n_187 ln_n_187  r=110.7
r394 xi18|mm0|bulk xi15|mm2|bulk  r=0.001
r393 xi18|mm0|bulk xi16|mm0|bulk  r=0.001
r392 xi18|mm0|bulk xi20|mm2|bulk  r=0.001
r391 xi18|mm0|bulk xi21|mm2|bulk  r=0.001
r390 xi18|mm0|bulk xi17|mm0|bulk  r=0.001
r389 xi18|mm0|bulk xi19|mm0|bulk  r=0.001
r388 xi18|mm0|bulk xi23|mm2|bulk  r=0.001
r387 ln_n_142 xi22|mm2|bulk  r=0.001
r386 ln_n_142 xi18|mm0|bulk  r=0.001
r385 326:net72 net72  r=0.119
r384 325:net72 326:net72  r=3.157
r383 324:net72 325:net72  r=0.266
r382 323:net72 328:net72  r=0.511
r381 323:net72 324:net72  r=0.266
r380 321:net72 322:net72  r=0.119
r379 320:net72 321:net72  r=3.164
r378 319:net72 327:net72  r=0.245
r377 319:net72 320:net72  r=0.266
r376 318:net72 327:net72  r=0.02
r375 317:net72 328:net72  r=1.21667
r374 317:net72 318:net72  r=0.49
r373 xi18|mm1|src 321:net72  r=18
r372 xi18|mm0|src 320:net72  r=18
r371 xi18|mm0|src 319:net72  r=18
r370 xi18|mm0|src 318:net72  r=18
r369 xi22|mm3|drn 326:net72  r=18
r368 xi22|mm2|drn 325:net72  r=18
r367 xi22|mm2|drn 324:net72  r=18
r366 xi22|mm2|drn 323:net72  r=18
r365 312:q 313:q  r=0.119
r364 310:q 311:q  r=0.266
r363 309:q 315:q  r=0.119
r362 309:q 310:q  r=0.266
r361 308:q 316:q  r=0.119
r360 307:q 311:q  r=0.385
r359 307:q 312:q  r=2.779
r358 307:q 308:q  r=0.399
r357 305:q 306:q  r=11.7
r356 xi23|mm3|drn 312:q  r=18
r355 xi23|mm2|drn 311:q  r=18
r354 xi23|mm2|drn 310:q  r=18
r353 xi23|mm2|drn 309:q  r=18
r352 xi22|mm3|gate 305:q  r=16.2
r351 304:q xi22|mm3|gate  r=16.2
r350 303:q q  r=11.7
r349 xi22|mm2|gate 314:q  r=32.4
r348 xi22|mm2|gate 303:q  r=32.4
r347 302:q 314:q  r=8.55001
r346 302:q 304:q  r=162.9
r345 301:q 302:q  r=31.95
r344 300:q 308:q  r=18
r343 300:q 301:q  r=3.7174
r342 299:q 300:q  r=3.7174
r341 296:ln_n_192 297:ln_n_192  r=7.43479
r340 295:ln_n_192 298:ln_n_192  r=207.45
r339 295:ln_n_192 296:ln_n_192  r=33.3
r338 295:ln_n_192 ln_n_192  r=85.0501
r337 292:ln_n_186 293:ln_n_186  r=7.43479
r336 291:ln_n_186 294:ln_n_186  r=180.45
r335 291:ln_n_186 292:ln_n_186  r=18.78
r334 291:ln_n_186 ln_n_186  r=110.7
r333 285:net71 288:net71  r=0.05
r332 283:net71 285:net71  r=1.21667
r331 283:net71 284:net71  r=0.05
r330 281:net71 282:net71  r=0.119
r329 279:net71 280:net71  r=0.266
r328 277:net71 278:net71  r=0.119
r327 276:net71 277:net71  r=3.192
r326 275:net71 276:net71  r=0.266
r325 274:net71 290:net71  r=0.119
r324 273:net71 289:net71  r=0.100333
r323 273:net71 285:net71  r=2
r322 272:net71 279:net71  r=0.23688
r321 271:net71 274:net71  r=0.434
r320 271:net71 280:net71  r=0.791
r319 271:net71 281:net71  r=2.422
r318 270:net71 287:net71  r=0.0903225
r317 270:net71 283:net71  r=2
r316 269:net71 270:net71  r=0.0948387
r315 268:net71 275:net71  r=0.245
r314 268:net71 269:net71  r=0.168965
r313 xi20|mm3|drn 281:net71  r=18
r312 xi20|mm2|drn 280:net71  r=18
r311 xi20|mm2|drn 279:net71  r=18
r310 xi20|mm2|drn 272:net71  r=18
r309 xi19|mm1|drn 277:net71  r=18
r308 xi19|mm0|drn 276:net71  r=18
r307 xi19|mm0|drn 275:net71  r=18
r306 xi19|mm0|drn 268:net71  r=18
r305 266:net71 xi21|mm3|gate  r=16.2
r304 265:net71 267:net71  r=11.7
r303 265:net71 xi21|mm3|gate  r=16.2
r302 264:net71 net71  r=11.7
r301 xi21|mm2|gate 286:net71  r=32.4
r300 xi21|mm2|gate 264:net71  r=32.4
r299 263:net71 286:net71  r=34.2
r298 263:net71 266:net71  r=137.25
r297 262:net71 263:net71  r=19.4897
r296 261:net71 274:net71  r=18
r295 261:net71 262:net71  r=3.7174
r294 260:net71 261:net71  r=3.7174
r293 259:net71 272:net71  r=0.17
r292 259:net71 273:net71  r=0.098
r291 256:net70 257:net70  r=1.15818
r290 255:net70 net70  r=0.119
r289 254:net70 255:net70  r=3.22
r288 253:net70 254:net70  r=0.266
r287 252:net70 257:net70  r=0.847
r286 252:net70 253:net70  r=0.266
r285 251:net70 258:net70  r=0.119
r284 250:net70 251:net70  r=3.164
r283 249:net70 250:net70  r=0.266
r282 248:net70 256:net70  r=0.847
r281 248:net70 249:net70  r=0.266
r280 xi21|mm3|drn 255:net70  r=18
r279 xi21|mm2|drn 254:net70  r=18
r278 xi21|mm2|drn 253:net70  r=18
r277 xi21|mm2|drn 252:net70  r=18
r276 xi17|mm1|src 251:net70  r=18
r275 xi17|mm0|src 250:net70  r=18
r274 xi17|mm0|src 249:net70  r=18
r273 xi17|mm0|src 248:net70  r=18
r272 241:net69 245:net69  r=0.05
r271 241:net69 242:net69  r=0.05
r270 240:net69 243:net69  r=0.084
r269 240:net69 241:net69  r=2
r268 237:net69 244:net69  r=0.05
r267 237:net69 238:net69  r=0.05
r266 236:net69 240:net69  r=1.61512
r265 236:net69 239:net69  r=0.0746666
r264 236:net69 237:net69  r=2
r263 234:net69 235:net69  r=0.119
r262 232:net69 233:net69  r=0.266
r261 231:net69 245:net69  r=0.413
r260 231:net69 232:net69  r=0.266
r259 230:net69 246:net69  r=0.119
r258 229:net69 230:net69  r=3.164
r257 228:net69 229:net69  r=0.266
r256 227:net69 244:net69  r=0.427
r255 227:net69 228:net69  r=0.266
r254 226:net69 247:net69  r=0.119
r253 225:net69 226:net69  r=0.434
r252 225:net69 233:net69  r=0.805
r251 225:net69 234:net69  r=2.394
r250 xi16|mm1|src 234:net69  r=18
r249 xi16|mm0|src 233:net69  r=18
r248 xi16|mm0|src 232:net69  r=18
r247 xi16|mm0|src 231:net69  r=18
r246 xi17|mm1|drn 230:net69  r=18
r245 xi17|mm0|drn 229:net69  r=18
r244 xi17|mm0|drn 228:net69  r=18
r243 xi17|mm0|drn 227:net69  r=18
r242 222:net69 xi20|mm3|gate  r=16.2
r241 221:net69 xi20|mm3|gate  r=16.2
r240 221:net69 223:net69  r=11.7
r239 220:net69 net69  r=11.7
r238 xi20|mm2|gate 224:net69  r=32.4
r237 xi20|mm2|gate 220:net69  r=32.4
r236 219:net69 224:net69  r=34.2
r235 219:net69 222:net69  r=136.35
r234 218:net69 219:net69  r=18.78
r233 217:net69 226:net69  r=18
r232 217:net69 218:net69  r=3.7174
r231 216:net69 217:net69  r=3.7174
r230 194:gnd! 210:gnd!  r=0.294
r229 193:gnd! 209:gnd!  r=0.05
r228 193:gnd! 194:gnd!  r=0.05
r227 192:gnd! 209:gnd!  r=0.294
r226 191:gnd! 208:gnd!  r=0.05
r225 191:gnd! 192:gnd!  r=0.05
r224 188:gnd! 210:gnd!  r=0.05
r223 188:gnd! 189:gnd!  r=0.05
r222 187:gnd! 195:gnd!  r=0.0373333
r221 187:gnd! 193:gnd!  r=2
r220 187:gnd! 191:gnd!  r=2
r219 187:gnd! 190:gnd!  r=0.0495384
r218 187:gnd! 188:gnd!  r=2
r217 184:gnd! 206:gnd!  r=0.294
r216 183:gnd! 196:gnd!  r=0.05
r215 183:gnd! 184:gnd!  r=0.05
r214 182:gnd! 207:gnd!  r=0.294
r213 181:gnd! 206:gnd!  r=0.05
r212 181:gnd! 182:gnd!  r=0.05
r211 179:gnd! 207:gnd!  r=0.05
r210 179:gnd! 180:gnd!  r=0.05
r209 178:gnd! 187:gnd!  r=0.260615
r208 178:gnd! 185:gnd!  r=0.0396666
r207 178:gnd! 183:gnd!  r=2
r206 178:gnd! 181:gnd!  r=2
r205 178:gnd! 179:gnd!  r=2
r204 177:gnd! 204:gnd!  r=0.294
r203 176:gnd! 203:gnd!  r=0.05
r202 176:gnd! 177:gnd!  r=0.05
r201 175:gnd! 205:gnd!  r=0.294
r200 174:gnd! 204:gnd!  r=0.05
r199 174:gnd! 175:gnd!  r=0.05
r198 172:gnd! 205:gnd!  r=0.05
r197 172:gnd! 173:gnd!  r=0.05
r196 171:gnd! 186:gnd!  r=0.042
r195 171:gnd! 178:gnd!  r=0.129949
r194 171:gnd! 176:gnd!  r=2
r193 171:gnd! 174:gnd!  r=2
r192 171:gnd! 172:gnd!  r=2
r191 169:gnd! 202:gnd!  r=0.294
r190 168:gnd! 201:gnd!  r=0.05
r189 168:gnd! 169:gnd!  r=0.05
r188 166:gnd! 202:gnd!  r=0.05
r187 166:gnd! 167:gnd!  r=0.05
r186 165:gnd! 201:gnd!  r=0.294
r185 164:gnd! 197:gnd!  r=0.05
r184 164:gnd! 165:gnd!  r=0.05
r183 163:gnd! 170:gnd!  r=0.042
r182 163:gnd! 168:gnd!  r=2
r181 163:gnd! 166:gnd!  r=2
r180 163:gnd! 164:gnd!  r=2
r179 160:gnd! 200:gnd!  r=0.294
r178 159:gnd! 199:gnd!  r=0.05
r177 159:gnd! 160:gnd!  r=0.05
r176 158:gnd! 199:gnd!  r=0.294
r175 157:gnd! 198:gnd!  r=0.05
r174 157:gnd! 158:gnd!  r=0.05
r173 155:gnd! 200:gnd!  r=0.05
r172 155:gnd! 156:gnd!  r=0.05
r171 154:gnd! 163:gnd!  r=0.0653333
r170 154:gnd! 162:gnd!  r=0.0396666
r169 154:gnd! 161:gnd!  r=0.231179
r168 154:gnd! 159:gnd!  r=2
r167 154:gnd! 157:gnd!  r=2
r166 154:gnd! 155:gnd!  r=2
r165 153:gnd! 215:gnd!  r=0.119
r164 153:gnd! 208:gnd!  r=0.539
r163 152:gnd! 213:gnd!  r=0.119
r162 152:gnd! 196:gnd!  r=0.532
r161 151:gnd! 214:gnd!  r=0.119
r160 151:gnd! 203:gnd!  r=0.518
r159 150:gnd! 212:gnd!  r=0.119
r158 150:gnd! 197:gnd!  r=0.574
r157 149:gnd! 211:gnd!  r=0.119
r156 149:gnd! 198:gnd!  r=0.588
r155 gnd! 171:gnd!  r=0.177865
r154 gnd! 163:gnd!  r=0.0885958
r153 xi15|mm3|src 153:gnd!  r=18
r152 xi20|mm3|src 152:gnd!  r=18
r151 xi21|mm3|src 151:gnd!  r=18
r150 xi23|mm3|src 150:gnd!  r=18
r149 xi22|mm3|src 149:gnd!  r=18
r148 147:ln_n_179 148:ln_n_179  r=3.78154
r147 146:ln_n_179 ln_n_179  r=0.196
r146 146:ln_n_179 147:ln_n_179  r=0.168965
r145 144:ln_n_157 145:ln_n_157  r=0.294
r144 143:ln_n_157 ln_n_157  r=0.707
r143 143:ln_n_157 144:ln_n_157  r=0.1
r142 142:ln_n_157 145:ln_n_157  r=0.1
r141 140:ln_n_157 142:ln_n_157  r=0.364
r140 140:ln_n_157 141:ln_n_157  r=0.098
r139 139:ln_n_157 140:ln_n_157  r=0.098
r138 138:ln_n_182 ln_n_182  r=1.533
r137 137:ln_n_182 138:ln_n_182  r=0.1
r136 136:ln_n_182 137:ln_n_182  r=0.308
r135 135:ln_n_182 136:ln_n_182  r=0.1
r134 133:ln_n_182 135:ln_n_182  r=0.378
r133 133:ln_n_182 134:ln_n_182  r=0.0886666
r132 132:ln_n_182 133:ln_n_182  r=0.107333
r131 130:ln_n_176 ln_n_176  r=1.036
r130 130:ln_n_176 131:ln_n_176  r=0.518
r129 129:ln_n_176 130:ln_n_176  r=2.898
r128 128:ln_n_177 ln_n_177  r=0.1
r127 127:ln_n_177 128:ln_n_177  r=0.7987
r126 126:ln_n_177 127:ln_n_177  r=0.7007
r125 123:ln_n_177 125:ln_n_177  r=0.098
r124 123:ln_n_177 124:ln_n_177  r=0.098
r123 122:ln_n_177 123:ln_n_177  r=0.364
r122 121:ln_n_177 ln_n_177  r=0.294
r121 121:ln_n_177 122:ln_n_177  r=0.1
r120 119:ln_n_156 120:ln_n_156  r=0.294
r119 118:ln_n_156 ln_n_156  r=0.693
r118 118:ln_n_156 119:ln_n_156  r=0.1
r117 117:ln_n_156 120:ln_n_156  r=0.1
r116 115:ln_n_156 117:ln_n_156  r=0.364
r115 115:ln_n_156 116:ln_n_156  r=0.0933333
r114 114:ln_n_156 115:ln_n_156  r=0.102667
r113 113:ln_n_175 ln_n_175  r=0.196
r112 112:ln_n_175 113:ln_n_175  r=0.173793
r111 110:ln_n_175 112:ln_n_175  r=0.903
r110 110:ln_n_175 111:ln_n_175  r=0.497
r109 109:ln_n_175 110:ln_n_175  r=2.926
r108 108:ln_n_170 ln_n_170  r=0.185161
r107 107:ln_n_170 108:ln_n_170  r=0.168965
r106 106:ln_n_170 107:ln_n_170  r=3.822
r105 104:ln_n_191 105:ln_n_191  r=7.43479
r104 103:ln_n_191 104:ln_n_191  r=33.3
r103 103:ln_n_191 ln_n_191  r=52.6501
r102 101:ln_n_189 102:ln_n_189  r=7.43479
r101 100:ln_n_189 101:ln_n_189  r=32.4
r100 100:ln_n_189 ln_n_189  r=85.0501
r99 98:ln_n_168 ln_n_168  r=4.312
r98 98:ln_n_168 99:ln_n_168  r=0.0886666
r97 97:ln_n_168 98:ln_n_168  r=0.107333
r96 96:ln_n_167 ln_n_167  r=1.582
r95 95:ln_n_167 96:ln_n_167  r=0.1
r94 94:ln_n_167 95:ln_n_167  r=0.294
r93 93:ln_n_167 94:ln_n_167  r=0.1
r92 91:ln_n_167 93:ln_n_167  r=0.364
r91 91:ln_n_167 92:ln_n_167  r=0.107333
r90 90:ln_n_167 91:ln_n_167  r=0.0886666
r89 88:ln_n_155 89:ln_n_155  r=0.294
r88 87:ln_n_155 ln_n_155  r=0.637
r87 87:ln_n_155 88:ln_n_155  r=0.1
r86 86:ln_n_155 89:ln_n_155  r=0.1
r85 84:ln_n_155 86:ln_n_155  r=0.364
r84 84:ln_n_155 85:ln_n_155  r=0.107333
r83 83:ln_n_155 84:ln_n_155  r=0.0886666
r82 81:ln_n_164 ln_n_164  r=1.316
r81 81:ln_n_164 82:ln_n_164  r=0.553
r80 80:ln_n_164 81:ln_n_164  r=2.541
r79 79:ln_n_164 ln_n_164  r=0.17
r78 78:ln_n_164 79:ln_n_164  r=0.198333
r77 76:ln_n_154 77:ln_n_154  r=0.294
r76 75:ln_n_154 ln_n_154  r=0.651
r75 75:ln_n_154 76:ln_n_154  r=0.1
r74 74:ln_n_154 77:ln_n_154  r=0.1
r73 72:ln_n_154 74:ln_n_154  r=0.364
r72 72:ln_n_154 73:ln_n_154  r=0.107333
r71 71:ln_n_154 72:ln_n_154  r=0.0886666
r70 70:ln_n_166 ln_n_166  r=1.582
r69 69:ln_n_166 70:ln_n_166  r=0.1
r68 68:ln_n_166 69:ln_n_166  r=0.294
r67 67:ln_n_166 68:ln_n_166  r=0.1
r66 65:ln_n_166 67:ln_n_166  r=0.364
r65 65:ln_n_166 66:ln_n_166  r=0.0886666
r64 64:ln_n_166 65:ln_n_166  r=0.107333
r63 62:ln_n_161 ln_n_161  r=0.102667
r62 62:ln_n_161 63:ln_n_161  r=0.0933333
r61 60:ln_n_161 62:ln_n_161  r=1.82
r60 60:ln_n_161 61:ln_n_161  r=0.553
r59 59:ln_n_161 60:ln_n_161  r=2.513
r58 57:ln_n_184 58:ln_n_184  r=7.43479
r57 56:ln_n_184 ln_n_184  r=141.75
r56 56:ln_n_184 57:ln_n_184  r=18.2727
r55 55:ln_n_159 ln_n_159  r=0.335517
r54 53:ln_n_159 55:ln_n_159  r=0.378
r53 53:ln_n_159 54:ln_n_159  r=3.514
r52 52:ln_n_159 53:ln_n_159  r=0.469
r51 50:ln_n_185 51:ln_n_185  r=7.43479
r50 49:ln_n_185 50:ln_n_185  r=32.4
r49 49:ln_n_185 ln_n_185  r=52.6501
r48 48:ln_n_163 ln_n_163  r=1.491
r47 47:ln_n_163 48:ln_n_163  r=0.1
r46 46:ln_n_163 47:ln_n_163  r=0.294
r45 45:ln_n_163 46:ln_n_163  r=0.1
r44 43:ln_n_163 45:ln_n_163  r=0.371
r43 43:ln_n_163 44:ln_n_163  r=0.112
r42 42:ln_n_163 43:ln_n_163  r=0.084
r41 40:ln_n_153 41:ln_n_153  r=0.294
r40 39:ln_n_153 ln_n_153  r=0.658
r39 39:ln_n_153 40:ln_n_153  r=0.1
r38 38:ln_n_153 41:ln_n_153  r=0.1
r37 36:ln_n_153 38:ln_n_153  r=0.364
r36 36:ln_n_153 37:ln_n_153  r=0.107333
r35 35:ln_n_153 36:ln_n_153  r=0.0886666
r34 33:ln_n_194 34:ln_n_194  r=7.43479
r33 32:ln_n_194 ln_n_194  r=85.0501
r32 32:ln_n_194 33:ln_n_194  r=32.4
r31 30:ln_n_190 31:ln_n_190  r=7.43479
r30 29:ln_n_190 ln_n_190  r=52.6501
r29 29:ln_n_190 30:ln_n_190  r=32.4
r28 27:ln_n_195 28:ln_n_195  r=7.43479
r27 26:ln_n_195 ln_n_195  r=52.6501
r26 26:ln_n_195 27:ln_n_195  r=32.85
r25 24:ln_n_188 25:ln_n_188  r=7.43479
r24 23:ln_n_188 24:ln_n_188  r=31.95
r23 23:ln_n_188 ln_n_188  r=85.0501
r22 22:ln_n_181 ln_n_181  r=0.526522
r21 21:ln_n_180 ln_n_180  r=0.848484
r20 20:ln_n_174 ln_n_174  r=0.355384
r19 19:ln_n_173 ln_n_173  r=0.2625
r18 18:ln_n_173 19:ln_n_173  r=0.1
r17 17:ln_n_173 18:ln_n_173  r=0.223125
r16 16:ln_n_165 ln_n_165  r=0.577949
r15 15:ln_n_162 ln_n_162  r=0.250303
r14 14:ln_n_162 15:ln_n_162  r=0.0823529
r13 13:ln_n_162 14:ln_n_162  r=0.241818
r12 12:ln_n_158 ln_n_158  r=0.267273
r11 11:ln_n_178 ln_n_178  r=4.319
r10 9:ln_n_178 11:ln_n_178  r=1.21667
r9 8:ln_n_178 10:ln_n_178  r=3.794
r8 8:ln_n_178 9:ln_n_178  r=0.51
r7 7:ln_n_172 ln_n_172  r=0.514706
r6 6:ln_n_171 ln_n_171  r=0.448823
r5 5:ln_n_171 6:ln_n_171  r=0.100867
r4 3:ln_n_169 4:ln_n_169  r=4.662
r3 2:ln_n_169 ln_n_169  r=4.718
r2 2:ln_n_169 3:ln_n_169  r=1.15818
r1 1:ln_n_160 ln_n_160  r=3.969
c1394 614:clkb 527:clk  c=6.71355e-18
c1393 614:clkb 372:ln_n_183  c=6.85093e-17
c1392 614:clkb 482:clk  c=1.6927e-17
c1391 614:clkb 371:ln_n_183  c=1.67861e-19
c1390 614:clkb 528:clk  c=1.59942e-17
c1389 614:clkb 535:clk  c=1.98363e-17
c1388 614:clkb 449:vdd!  c=2.61212e-17
c1387 614:clkb 509:clk  c=2.52846e-18
c1386 614:clkb 478:clk  c=5.51917e-18
c1385 614:clkb 510:clk  c=1.63994e-18
c1384 614:clkb 529:clk  c=1.45192e-18
c1383 614:clkb 520:clk  c=9.43762e-18
c1382 614:clkb vdd!  c=9.84368e-18
c1381 614:clkb 474:clk  c=4.83705e-18
c1380 614:clkb 225:net69  c=2.21295e-18
c1379 614:clkb 536:clk  c=1.10158e-18
c1378 614:clkb xi18|mm1|bulk  c=1.96907e-17
c1377 614:clkb 50:ln_n_185  c=6.99095e-19
c1376 614:clkb 541:d  c=2.60017e-17
c1375 614:clkb 513:clk  c=1.15159e-16
c1374 614:clkb 51:ln_n_185  c=5.1468e-19
c1373 614:clkb 369:ln_n_183  c=8.13392e-17
c1372 613:clkb xi18|mm1|bulk  c=2.0148e-18
c1371 613:clkb 478:clk  c=4.26412e-18
c1370 613:clkb 257:net70  c=3.33351e-18
c1369 613:clkb 533:clk  c=1.05962e-17
c1368 613:clkb 463:clk  c=5.42965e-19
c1367 613:clkb 271:net71  c=2.24926e-24
c1366 613:clkb 246:net69  c=4.23247e-18
c1365 613:clkb 258:net70  c=2.07056e-19
c1364 612:clkb 288:net71  c=7.2531e-18
c1363 612:clkb 258:net70  c=3.11968e-18
c1362 612:clkb 24:ln_n_188  c=2.53755e-17
c1361 612:clkb 246:net69  c=3.95445e-17
c1360 612:clkb 25:ln_n_188  c=2.97139e-17
c1359 612:clkb 272:net71  c=2.86905e-19
c1358 612:clkb 244:net69  c=2.31141e-19
c1357 612:clkb 290:net71  c=8.49543e-19
c1356 612:clkb 271:net71  c=6.74779e-24
c1355 612:clkb 256:net70  c=6.55675e-19
c1354 612:clkb 257:net70  c=3.71501e-17
c1353 612:clkb 240:net69  c=5.40423e-19
c1352 612:clkb xi18|mm1|bulk  c=1.02944e-17
c1351 611:clkb 288:net71  c=2.93579e-18
c1350 611:clkb 258:net70  c=3.95982e-17
c1349 611:clkb 24:ln_n_188  c=5.82189e-19
c1348 611:clkb 246:net69  c=3.12235e-18
c1347 611:clkb 348:net75  c=1.61609e-19
c1346 611:clkb 368:net75  c=5.41864e-19
c1345 611:clkb 347:net75  c=2.70344e-18
c1344 611:clkb 268:net71  c=4.08425e-17
c1343 611:clkb 101:ln_n_189  c=2.48755e-17
c1342 611:clkb 102:ln_n_189  c=2.96541e-17
c1341 611:clkb xi18|mm1|bulk  c=1.1857e-17
c1340 611:clkb 287:net71  c=3.41314e-18
c1339 611:clkb 523:clk  c=4.25432e-20
c1338 610:clkb 288:net71  c=1.69102e-17
c1337 610:clkb 258:net70  c=1.16219e-16
c1336 610:clkb 259:net71  c=4.69862e-19
c1335 610:clkb 24:ln_n_188  c=7.72946e-19
c1334 610:clkb 246:net69  c=1.14616e-16
c1333 610:clkb 428:vdd!  c=2.5147e-19
c1332 610:clkb 290:net71  c=3.06765e-17
c1331 610:clkb 271:net71  c=1.17609e-16
c1330 610:clkb 445:vdd!  c=4.4329e-18
c1329 610:clkb 533:clk  c=1.62312e-18
c1328 610:clkb 256:net70  c=3.86297e-19
c1327 610:clkb 257:net70  c=1.18649e-16
c1326 610:clkb 478:clk  c=1.21646e-16
c1325 610:clkb 294:ln_n_186  c=2.3294e-19
c1324 610:clkb 240:net69  c=4.16061e-18
c1323 610:clkb 446:vdd!  c=4.10852e-18
c1322 610:clkb 448:vdd!  c=1.53099e-19
c1321 610:clkb 347:net75  c=3.17967e-18
c1320 610:clkb 292:ln_n_186  c=7.73848e-20
c1319 610:clkb 510:clk  c=6.99122e-18
c1318 610:clkb 268:net71  c=1.48111e-17
c1317 610:clkb 529:clk  c=5.32771e-19
c1316 610:clkb 239:net69  c=3.06774e-19
c1315 610:clkb vdd!  c=3.93234e-19
c1314 610:clkb 247:net69  c=7.77082e-18
c1313 610:clkb 225:net69  c=6.16649e-18
c1312 610:clkb xi18|mm1|bulk  c=3.41143e-17
c1311 610:clkb 287:net71  c=2.03937e-19
c1310 610:clkb 513:clk  c=3.13874e-18
c1309 610:clkb 541:d  c=6.06934e-19
c1308 609:clkb 501:clk  c=1.11599e-19
c1307 609:clkb xi18|mm1|bulk  c=1.29538e-18
c1306 609:clkb 225:net69  c=1.07548e-18
c1305 609:clkb 534:clk  c=4.73365e-19
c1304 609:clkb 510:clk  c=2.0067e-17
c1303 609:clkb 505:clk  c=3.72719e-20
c1302 609:clkb 478:clk  c=9.51271e-19
c1301 609:clkb 257:net70  c=5.44889e-21
c1300 609:clkb 271:net71  c=1.38244e-18
c1299 608:clkb 527:clk  c=4.13518e-23
c1298 608:clkb 372:ln_n_183  c=1.94348e-18
c1297 608:clkb 535:clk  c=1.05771e-17
c1296 608:clkb 510:clk  c=4.13403e-18
c1295 608:clkb 225:net69  c=8.81887e-19
c1294 608:clkb xi18|mm1|bulk  c=2.69417e-18
c1293 608:clkb 541:d  c=2.0096e-17
c1292 608:clkb 51:ln_n_185  c=3.60748e-18
c1291 607:clkb 271:net71  c=4.27863e-18
c1290 607:clkb 445:vdd!  c=2.38452e-18
c1289 607:clkb 257:net70  c=1.06867e-19
c1288 607:clkb 478:clk  c=6.11499e-18
c1287 607:clkb 294:ln_n_186  c=1.93322e-17
c1286 607:clkb 240:net69  c=5.80862e-19
c1285 607:clkb 292:ln_n_186  c=1.55069e-17
c1284 607:clkb 293:ln_n_186  c=1.86305e-18
c1283 607:clkb 247:net69  c=6.28395e-18
c1282 607:clkb 225:net69  c=5.97291e-18
c1281 607:clkb 541:d  c=3.30059e-19
c1280 606:clkb 258:net70  c=1.83728e-17
c1279 606:clkb 246:net69  c=8.62373e-19
c1278 606:clkb xi17|mm0|src  c=1.06093e-20
c1277 606:clkb 478:clk  c=7.00223e-18
c1276 606:clkb 347:net75  c=1.88596e-18
c1275 606:clkb 268:net71  c=2.00725e-17
c1274 606:clkb 101:ln_n_189  c=6.08895e-19
c1273 606:clkb 102:ln_n_189  c=2.2202e-18
c1272 606:clkb 480:clk  c=1.9629e-19
c1271 606:clkb xi18|mm1|bulk  c=6.77976e-18
c1270 606:clkb 287:net71  c=9.9477e-20
c1269 606:clkb 523:clk  c=3.47272e-18
c1268 605:clkb 366:net75  c=5.9103e-18
c1267 605:clkb 501:clk  c=6.67726e-19
c1266 605:clkb 478:clk  c=8.26012e-18
c1265 605:clkb 510:clk  c=8.59314e-19
c1264 605:clkb xi18|mm1|bulk  c=5.92971e-18
c1263 605:clkb 307:q  c=1.02791e-21
c1262 605:clkb 327:net72  c=9.97075e-19
c1261 605:clkb 328:net72  c=2.42001e-18
c1260 604:clkb 28:ln_n_195  c=2.92058e-18
c1259 604:clkb xi22|mm2|drn  c=4.56179e-21
c1258 604:clkb 462:clk  c=5.73802e-18
c1257 604:clkb 328:net72  c=1.67993e-17
c1256 604:clkb 211:gnd!  c=2.13317e-19
c1255 604:clkb 478:clk  c=2.11227e-18
c1254 604:clkb xi22|mm3|drn  c=9.3148e-21
c1253 604:clkb 26:ln_n_195  c=1.13958e-18
c1252 604:clkb xi18|mm1|bulk  c=4.06048e-18
c1251 604:clkb 327:net72  c=1.29365e-18
c1250 604:clkb 307:q  c=2.08437e-23
c1249 604:clkb 366:net75  c=2.08914e-17
c1248 603:clkb 258:net70  c=7.18644e-19
c1247 603:clkb 24:ln_n_188  c=5.85224e-19
c1246 603:clkb 246:net69  c=1.48691e-17
c1245 603:clkb 25:ln_n_188  c=2.24397e-18
c1244 603:clkb 271:net71  c=3.2235e-23
c1243 603:clkb xi21|mm2|drn  c=7.57807e-21
c1242 603:clkb 533:clk  c=7.21455e-19
c1241 603:clkb 256:net70  c=2.34937e-20
c1240 603:clkb 257:net70  c=1.30268e-17
c1239 603:clkb xi18|mm1|bulk  c=1.87191e-18
c1238 598:clkb 246:net69  c=3.80322e-19
c1237 598:clkb 258:net70  c=1.05427e-17
c1236 598:clkb 288:net71  c=2.33751e-19
c1235 598:clkb 256:net70  c=3.7778e-19
c1234 598:clkb 244:net69  c=2.12149e-18
c1233 598:clkb 100:ln_n_189  c=1.05916e-18
c1232 597:clkb 366:net75  c=9.74346e-19
c1231 597:clkb 365:net75  c=2.19902e-20
c1230 597:clkb 327:net72  c=5.04733e-18
c1229 597:clkb 317:net72  c=3.37583e-20
c1228 596:clkb 541:d  c=5.23669e-18
c1227 596:clkb 372:ln_n_183  c=4.48703e-19
c1226 596:clkb 294:ln_n_186  c=5.29579e-19
c1225 596:clkb 51:ln_n_185  c=4.06698e-19
c1224 596:clkb 50:ln_n_185  c=5.77333e-18
c1223 596:clkb gnd!  c=1.22642e-18
c1222 596:clkb 225:net69  c=4.93483e-18
c1221 595:clkb 363:net75  c=2.67395e-18
c1220 595:clkb vdd!  c=9.26731e-19
c1219 595:clkb 348:net75  c=5.0969e-18
c1218 594:clkb 541:d  c=2.84082e-18
c1217 594:clkb gnd!  c=5.57674e-18
c1216 594:clkb 225:net69  c=1.36476e-19
c1215 594:clkb xi18|mm1|bulk  c=3.19947e-18
c1214 594:clkb 510:clk  c=9.7241e-19
c1213 591:clkb 271:net71  c=3.34204e-18
c1212 591:clkb 257:net70  c=1.45931e-19
c1211 591:clkb 478:clk  c=2.0046e-18
c1210 591:clkb 505:clk  c=4.57428e-20
c1209 591:clkb 510:clk  c=5.54394e-17
c1208 591:clkb gnd!  c=1.00188e-17
c1207 591:clkb 225:net69  c=1.13808e-16
c1206 591:clkb xi18|mm1|bulk  c=9.57308e-18
c1205 591:clkb 501:clk  c=2.587e-18
c1204 591:clkb 50:ln_n_185  c=9.98857e-19
c1203 591:clkb 541:d  c=9.73422e-17
c1202 580:clkb 366:net75  c=3.56284e-18
c1201 580:clkb 211:gnd!  c=3.86556e-20
c1200 580:clkb 328:net72  c=3.21598e-18
c1199 580:clkb 327:net72  c=1.54622e-19
c1198 580:clkb gnd!  c=8.51574e-18
c1197 580:clkb xi18|mm1|bulk  c=4.13728e-18
c1196 566:clkb 372:ln_n_183  c=1.55209e-17
c1195 566:clkb 473:clk  c=3.17392e-18
c1194 566:clkb 213:gnd!  c=2.47658e-20
c1193 566:clkb 215:gnd!  c=1.29612e-17
c1192 566:clkb gnd!  c=1.62666e-17
c1191 566:clkb 225:net69  c=7.60779e-19
c1190 566:clkb xi18|mm1|bulk  c=3.84761e-18
c1189 566:clkb 50:ln_n_185  c=3.61554e-20
c1188 566:clkb 541:d  c=7.81171e-18
c1187 566:clkb 51:ln_n_185  c=1.57039e-18
c1186 566:clkb 49:ln_n_185  c=1.29368e-18
c1185 565:clkb 372:ln_n_183  c=7.33906e-18
c1184 565:clkb 473:clk  c=8.27942e-19
c1183 565:clkb 535:clk  c=1.31733e-19
c1182 565:clkb gnd!  c=7.09802e-18
c1181 565:clkb 225:net69  c=1.16772e-18
c1180 565:clkb xi18|mm1|bulk  c=7.4335e-18
c1179 565:clkb 513:clk  c=5.64953e-19
c1178 565:clkb 50:ln_n_185  c=2.40799e-17
c1177 565:clkb 541:d  c=2.00769e-17
c1176 565:clkb 51:ln_n_185  c=2.97047e-17
c1175 565:clkb 49:ln_n_185  c=1.00506e-19
c1174 563:clkb 271:net71  c=1.61912e-17
c1173 563:clkb 445:vdd!  c=1.4834e-19
c1172 563:clkb 213:gnd!  c=5.01748e-18
c1171 563:clkb 257:net70  c=2.6447e-19
c1170 563:clkb 196:gnd!  c=1.75057e-19
c1169 563:clkb 478:clk  c=1.22228e-16
c1168 563:clkb 294:ln_n_186  c=5.78917e-17
c1167 563:clkb 221:net69  c=1.01566e-18
c1166 563:clkb 510:clk  c=2.23898e-17
c1165 563:clkb 247:net69  c=8.27206e-23
c1164 563:clkb 225:net69  c=1.23163e-17
c1163 563:clkb xi18|mm1|bulk  c=7.20053e-18
c1162 563:clkb 541:d  c=5.33174e-19
c1161 562:clkb 28:ln_n_195  c=2.49876e-17
c1160 562:clkb 462:clk  c=2.33713e-19
c1159 562:clkb 328:net72  c=1.74115e-17
c1158 562:clkb 162:gnd!  c=2.96744e-21
c1157 562:clkb 170:gnd!  c=5.19824e-22
c1156 562:clkb 211:gnd!  c=3.02525e-18
c1155 562:clkb xi22|mm3|drn  c=2.00508e-19
c1154 562:clkb gnd!  c=3.76486e-17
c1153 562:clkb 26:ln_n_195  c=3.74448e-17
c1152 562:clkb xi18|mm1|bulk  c=6.72621e-18
c1151 562:clkb 327:net72  c=1.16929e-18
c1150 562:clkb 307:q  c=4.38875e-21
c1149 562:clkb 366:net75  c=1.68343e-17
c1148 562:clkb 212:gnd!  c=4.70308e-20
c1147 557:clkb 258:net70  c=8.96186e-17
c1146 557:clkb 185:gnd!  c=8.43275e-18
c1145 557:clkb 246:net69  c=8.98305e-17
c1144 557:clkb 271:net71  c=1.14977e-16
c1143 557:clkb 525:clk  c=2.64396e-17
c1142 557:clkb 213:gnd!  c=3.10052e-17
c1141 557:clkb 532:clk  c=6.57005e-17
c1140 557:clkb 328:net72  c=9.12624e-17
c1139 557:clkb 197:gnd!  c=6.96876e-19
c1138 557:clkb 162:gnd!  c=6.8737e-18
c1137 557:clkb 207:gnd!  c=2.69464e-21
c1136 557:clkb 201:gnd!  c=1.04506e-20
c1135 557:clkb 206:gnd!  c=2.08722e-21
c1134 557:clkb 211:gnd!  c=3.95404e-17
c1133 557:clkb 257:net70  c=1.02124e-16
c1132 557:clkb 170:gnd!  c=6.94995e-18
c1131 557:clkb 478:clk  c=4.77842e-17
c1130 557:clkb 517:clk  c=8.4439e-19
c1129 557:clkb 200:gnd!  c=2.84111e-21
c1128 557:clkb 519:clk  c=8.96611e-19
c1127 557:clkb 347:net75  c=1.08282e-16
c1126 557:clkb 214:gnd!  c=2.71393e-17
c1125 557:clkb 505:clk  c=9.51271e-19
c1124 557:clkb 510:clk  c=2.73029e-17
c1123 557:clkb 198:gnd!  c=6.87588e-19
c1122 557:clkb 268:net71  c=9.85203e-17
c1121 557:clkb 205:gnd!  c=5.33595e-21
c1120 557:clkb gnd!  c=7.30553e-17
c1119 557:clkb 480:clk  c=9.32466e-17
c1118 557:clkb 534:clk  c=9.51271e-19
c1117 557:clkb 225:net69  c=6.76296e-18
c1116 557:clkb 501:clk  c=6.92934e-17
c1115 557:clkb xi18|mm1|bulk  c=5.7558e-17
c1114 557:clkb 327:net72  c=4.52032e-19
c1113 557:clkb 204:gnd!  c=2.07815e-21
c1112 557:clkb 307:q  c=1.08828e-16
c1111 557:clkb 541:d  c=3.29721e-19
c1110 557:clkb 203:gnd!  c=6.96876e-19
c1109 557:clkb 366:net75  c=3.46232e-18
c1108 557:clkb 212:gnd!  c=3.76618e-17
c1107 557:clkb 186:gnd!  c=7.11828e-18
c1106 xi15|mm3|drn 372:ln_n_183  c=3.37496e-17
c1105 xi15|mm3|drn 51:ln_n_185  c=2.9333e-18
c1104 xi15|mm3|drn 49:ln_n_185  c=8.53147e-19
c1103 xi15|mm3|drn xi15|mm3|src  c=4.84074e-17
c1102 xi15|mm3|drn xi16|mm1|src  c=4.35704e-20
c1101 xi15|mm3|drn xi16|mm1|drn  c=1.36623e-17
c1100 xi15|mm2|drn 528:clk  c=7.58411e-21
c1099 xi15|mm2|drn xi15|mm2|src  c=9.35155e-17
c1098 xi15|mm2|drn xi16|mm0|src  c=8.48477e-20
c1097 xi15|mm2|drn 369:ln_n_183  c=7.19279e-17
c1096 xi15|mm2|drn xi16|mm0|drn  c=2.81489e-17
cg1095 541:d 0  c=4.79883e-17
c1094 541:d 56:ln_n_184  c=6.20361e-17
c1093 541:d 527:clk  c=8.65411e-18
c1092 541:d 482:clk  c=1.59845e-17
c1091 541:d 528:clk  c=2.14054e-17
c1090 541:d 535:clk  c=1.83801e-17
c1089 541:d 509:clk  c=2.73241e-18
c1088 541:d 478:clk  c=8.76965e-17
c1087 541:d 510:clk  c=1.87202e-17
c1086 541:d 247:net69  c=3.36494e-18
c1085 541:d 57:ln_n_184  c=4.84543e-17
c1084 541:d 225:net69  c=9.09396e-17
c1083 541:d 58:ln_n_184  c=2.45668e-18
c1082 541:d 50:ln_n_185  c=3.69789e-17
c1081 541:d 513:clk  c=5.30974e-18
c1080 541:d 51:ln_n_185  c=3.40536e-18
c1079 541:d 49:ln_n_185  c=1.32268e-17
cg1078 xi16|mm1|drn 0  c=8.61271e-19
c1077 xi16|mm1|drn 51:ln_n_185  c=3.51807e-18
c1076 xi16|mm1|drn 50:ln_n_185  c=2.34675e-17
c1075 xi16|mm1|drn 49:ln_n_185  c=2.0948e-17
c1074 xi16|mm1|drn xi16|mm1|src  c=4.84775e-17
c1073 xi16|mm1|drn xi17|mm1|drn  c=1.25061e-22
cg1072 xi16|mm0|drn 0  c=1.93075e-18
c1071 xi16|mm0|drn 50:ln_n_185  c=2.58831e-23
c1070 xi16|mm0|drn 57:ln_n_184  c=3.37976e-18
c1069 xi16|mm0|drn 56:ln_n_184  c=4.65256e-17
c1068 xi16|mm0|drn xi16|mm0|src  c=9.35155e-17
c1067 536:clk 371:ln_n_183  c=4.51961e-18
c1066 536:clk xi18|mm1|bulk  c=6.2399e-18
c1065 536:clk 369:ln_n_183  c=1.00959e-17
c1064 535:clk 372:ln_n_183  c=1.95939e-18
c1063 535:clk 57:ln_n_184  c=1.70096e-21
c1062 535:clk 225:net69  c=8.62373e-19
c1061 535:clk 58:ln_n_184  c=3.82084e-18
c1060 535:clk xi18|mm1|bulk  c=3.04747e-18
c1059 534:clk 246:net69  c=1.42841e-18
c1058 534:clk 258:net70  c=1.13492e-19
c1057 534:clk xi18|mm1|bulk  c=3.13664e-18
c1056 534:clk 257:net70  c=1.32523e-18
c1055 534:clk 271:net71  c=1.68187e-21
c1054 533:clk 258:net70  c=8.53267e-19
c1053 533:clk 246:net69  c=1.73104e-17
c1052 533:clk 271:net71  c=3.24236e-23
c1051 533:clk xi21|mm2|drn  c=1.51866e-21
c1050 533:clk 257:net70  c=1.64484e-17
c1049 533:clk xi18|mm1|bulk  c=3.82572e-18
c1048 532:clk 258:net70  c=3.32718e-20
c1047 532:clk 246:net69  c=5.88865e-18
c1046 532:clk 271:net71  c=2.42644e-23
c1045 532:clk 104:ln_n_191  c=1.69854e-17
c1044 532:clk 105:ln_n_191  c=2.03384e-17
c1043 532:clk 257:net70  c=1.01214e-17
c1042 532:clk 103:ln_n_191  c=1.4744e-19
c1041 532:clk xi18|mm1|bulk  c=2.12482e-18
c1040 531:clk 366:net75  c=2.65653e-18
c1039 531:clk 307:q  c=2.28279e-21
c1038 531:clk 327:net72  c=1.0507e-18
c1037 531:clk xi18|mm1|bulk  c=3.84521e-18
c1036 531:clk 337:net75  c=2.72499e-19
c1035 531:clk 328:net72  c=2.36917e-18
c1034 531:clk 360:net75  c=2.00575e-18
c1033 530:clk 364:net75  c=5.41888e-23
c1032 530:clk 365:net75  c=3.83837e-18
c1031 530:clk 360:net75  c=6.15124e-18
c1030 530:clk 328:net72  c=1.652e-17
c1029 530:clk 315:q  c=3.49428e-20
c1028 530:clk 316:q  c=3.85251e-19
c1027 530:clk xi18|mm1|bulk  c=2.964e-18
c1026 530:clk 327:net72  c=8.08885e-19
c1025 530:clk 307:q  c=9.60927e-20
c1024 530:clk 33:ln_n_194  c=2.3707e-17
c1023 530:clk 366:net75  c=1.20525e-17
c1022 530:clk 34:ln_n_194  c=1.3962e-17
c1021 529:clk xi18|mm1|bulk  c=3.41634e-18
c1020 528:clk 56:ln_n_184  c=2.00032e-18
c1019 528:clk 57:ln_n_184  c=4.98942e-18
c1018 528:clk 247:net69  c=4.61082e-19
c1017 528:clk 225:net69  c=5.81384e-19
c1016 528:clk xi18|mm1|bulk  c=6.51371e-18
c1015 528:clk 369:ln_n_183  c=1.73966e-18
c1014 527:clk 372:ln_n_183  c=1.09841e-18
c1013 527:clk 57:ln_n_184  c=2.68769e-18
c1012 527:clk 225:net69  c=4.98107e-19
c1011 527:clk 58:ln_n_184  c=1.41004e-17
c1010 527:clk xi18|mm1|bulk  c=2.18857e-18
c1009 527:clk 369:ln_n_183  c=1.54228e-19
c1008 525:clk 258:net70  c=2.52596e-19
c1007 525:clk 246:net69  c=6.37719e-18
c1006 525:clk 271:net71  c=4.52496e-25
c1005 525:clk 104:ln_n_191  c=4.57315e-18
c1004 525:clk 105:ln_n_191  c=1.14516e-17
c1003 525:clk 257:net70  c=5.36448e-18
c1002 525:clk xi18|mm1|bulk  c=1.84586e-18
c1001 523:clk 258:net70  c=1.7625e-17
c1000 523:clk 246:net69  c=8.53267e-19
c999 523:clk 347:net75  c=1.52462e-18
c998 523:clk 268:net71  c=2.02575e-17
c997 523:clk 30:ln_n_190  c=4.61443e-21
c996 523:clk xi18|mm1|bulk  c=5.44615e-18
c995 523:clk 31:ln_n_190  c=3.75195e-18
c994 520:clk 56:ln_n_184  c=1.05916e-18
c993 519:clk 246:net69  c=3.58138e-19
c992 519:clk 258:net70  c=5.26098e-18
c991 519:clk 104:ln_n_191  c=5.69251e-18
c990 519:clk 31:ln_n_190  c=3.32753e-19
c989 519:clk 29:ln_n_190  c=4.63408e-19
c988 518:clk 245:net69  c=2.46614e-18
c987 518:clk 225:net69  c=9.1046e-18
c986 517:clk 30:ln_n_190  c=5.69945e-18
c985 517:clk 347:net75  c=5.00502e-18
c984 517:clk 268:net71  c=3.58138e-19
c983 516:clk 327:net72  c=6.78643e-18
c982 516:clk 317:net72  c=4.89096e-18
c981 513:clk 247:net69  c=3.42365e-19
c980 513:clk 225:net69  c=6.43066e-19
c979 513:clk xi18|mm1|bulk  c=1.55379e-17
c978 510:clk 258:net70  c=1.46891e-18
c977 510:clk 246:net69  c=1.40869e-18
c976 510:clk 271:net71  c=2.91324e-17
c975 510:clk 265:net71  c=4.59957e-20
c974 510:clk 328:net72  c=1.40475e-18
c973 510:clk 243:net69  c=1.86421e-19
c972 510:clk 257:net70  c=2.28697e-17
c971 510:clk 240:net69  c=3.28002e-20
c970 510:clk 337:net75  c=1.09345e-18
c969 510:clk 347:net75  c=1.47822e-18
c968 510:clk 268:net71  c=1.45601e-18
c967 510:clk 225:net69  c=2.26282e-17
c966 510:clk xi18|mm1|bulk  c=1.32736e-17
c965 510:clk 307:q  c=1.47377e-18
c964 510:clk 366:net75  c=7.485e-20
c963 509:clk 225:net69  c=4.42693e-20
c962 509:clk xi18|mm1|bulk  c=7.87678e-18
c961 505:clk 246:net69  c=1.07373e-19
c960 505:clk 258:net70  c=1.24327e-18
c959 505:clk xi18|mm1|bulk  c=4.12313e-18
c958 505:clk 347:net75  c=1.55793e-19
c957 505:clk 268:net71  c=1.81663e-18
c956 501:clk 258:net70  c=9.47776e-17
c955 501:clk 246:net69  c=9.29603e-17
c954 501:clk 104:ln_n_191  c=1.22545e-18
c953 501:clk 271:net71  c=2.20805e-19
c952 501:clk 257:net70  c=5.30586e-18
c951 501:clk 347:net75  c=1.49944e-18
c950 501:clk 268:net71  c=7.72583e-18
c949 501:clk xi18|mm1|bulk  c=7.21652e-18
c948 482:clk 57:ln_n_184  c=3.4675e-17
c947 482:clk 56:ln_n_184  c=1.17544e-18
c946 482:clk 369:ln_n_183  c=1.50464e-18
c945 482:clk xi18|mm1|bulk  c=2.71362e-18
c944 482:clk 225:net69  c=9.01758e-19
c943 480:clk 258:net70  c=1.40128e-17
c942 480:clk 246:net69  c=3.07346e-19
c941 480:clk 104:ln_n_191  c=1.41632e-19
c940 480:clk 347:net75  c=6.21871e-19
c939 480:clk 268:net71  c=1.44345e-17
c938 480:clk 103:ln_n_191  c=1.60232e-19
c937 480:clk 29:ln_n_190  c=1.34594e-19
c936 480:clk 30:ln_n_190  c=2.19093e-17
c935 480:clk 31:ln_n_190  c=3.11421e-17
c934 480:clk xi18|mm1|bulk  c=4.33585e-18
c933 478:clk 316:q  c=6.54706e-18
c932 478:clk 307:q  c=1.26184e-16
c931 478:clk 243:net69  c=1.47626e-18
c930 478:clk 290:net71  c=4.0899e-18
c929 478:clk 271:net71  c=8.51084e-17
c928 478:clk 305:q  c=4.59255e-20
c927 478:clk 368:net75  c=6.28947e-18
c926 478:clk 347:net75  c=1.26654e-16
c925 478:clk 268:net71  c=1.22266e-16
c924 478:clk 327:net72  c=2.80042e-18
c923 478:clk 345:net75  c=4.59537e-20
c922 478:clk 366:net75  c=8.04972e-18
c921 478:clk 287:net71  c=2.2899e-20
c920 478:clk 360:net75  c=3.00922e-19
c919 478:clk 247:net69  c=7.24499e-18
c918 478:clk 225:net69  c=9.2589e-17
c917 478:clk 258:net70  c=1.10415e-16
c916 478:clk 245:net69  c=2.98803e-19
c915 478:clk 246:net69  c=1.0211e-16
c914 478:clk 244:net69  c=1.12568e-19
c913 478:clk 30:ln_n_190  c=6.84969e-19
c912 478:clk 328:net72  c=1.15357e-16
c911 478:clk 240:net69  c=9.16508e-19
c910 478:clk 337:net75  c=1.0117e-17
c909 478:clk 257:net70  c=8.41559e-17
c908 478:clk 104:ln_n_191  c=2.83417e-19
c907 478:clk xi18|mm1|bulk  c=7.32386e-17
c906 478:clk 288:net71  c=1.45627e-18
c905 474:clk 372:ln_n_183  c=4.83649e-19
c904 474:clk 371:ln_n_183  c=1.51857e-17
c903 474:clk 57:ln_n_184  c=3.15349e-19
c902 474:clk xi18|mm1|bulk  c=6.20443e-18
c901 474:clk 369:ln_n_183  c=5.58856e-17
c900 473:clk 369:ln_n_183  c=7.15995e-19
c899 463:clk 246:net69  c=2.36839e-17
c898 463:clk 258:net70  c=1.06725e-18
c897 463:clk 257:net70  c=2.1634e-17
c896 463:clk 105:ln_n_191  c=4.01428e-18
c895 463:clk 271:net71  c=3.41231e-23
c894 463:clk xi18|mm1|bulk  c=5.55792e-18
c893 462:clk xi22|mm2|drn  c=4.55563e-21
c892 462:clk 365:net75  c=2.6884e-19
c891 462:clk 328:net72  c=6.95533e-17
c890 462:clk 316:q  c=1.62624e-19
c889 462:clk xi18|mm1|bulk  c=1.9163e-17
c888 462:clk 327:net72  c=8.37514e-18
c887 462:clk 307:q  c=5.2603e-19
c886 462:clk 366:net75  c=8.54004e-17
c885 462:clk 33:ln_n_194  c=2.32095e-18
c884 462:clk 34:ln_n_194  c=1.75542e-17
cg883 450:vdd! 0  c=3.47319e-18
c882 450:vdd! xi18|mm1|bulk  c=3.14766e-18
c881 450:vdd! 369:ln_n_183  c=1.97712e-18
cg880 449:vdd! 0  c=4.11183e-17
c879 449:vdd! 243:net69  c=8.04946e-19
c878 449:vdd! 240:net69  c=1.98376e-18
c877 449:vdd! 225:net69  c=4.71554e-19
c876 449:vdd! xi18|mm1|bulk  c=1.69549e-17
c875 449:vdd! 245:net69  c=1.6939e-18
c874 449:vdd! 369:ln_n_183  c=3.54519e-17
c873 448:vdd! 247:net69  c=2.24121e-19
c872 448:vdd! 291:ln_n_186  c=1.39987e-18
c871 448:vdd! 293:ln_n_186  c=2.14827e-19
c870 448:vdd! 240:net69  c=6.29577e-18
c869 448:vdd! xi18|mm1|bulk  c=3.57262e-18
c868 448:vdd! 224:net69  c=1.09222e-18
c867 447:vdd! 289:net71  c=4.2037e-19
c866 447:vdd! 288:net71  c=2.83663e-19
c865 447:vdd! 329:ln_n_187  c=1.52201e-18
c864 447:vdd! 240:net69  c=5.5582e-18
c863 447:vdd! xi18|mm1|bulk  c=3.31924e-18
c862 447:vdd! 286:net71  c=1.19198e-18
c861 447:vdd! 256:net70  c=5.83502e-18
cg860 446:vdd! 0  c=9.91922e-18
c859 446:vdd! 288:net71  c=1.07834e-16
c858 446:vdd! 259:net71  c=1.61649e-17
c857 446:vdd! 246:net69  c=9.61666e-19
c856 446:vdd! 272:net71  c=8.3846e-18
c855 446:vdd! 244:net69  c=3.72945e-19
c854 446:vdd! 265:net71  c=4.64558e-20
c853 446:vdd! 243:net69  c=1.81123e-20
c852 446:vdd! 330:ln_n_187  c=5.77446e-18
c851 446:vdd! 256:net70  c=2.60547e-18
c850 446:vdd! 257:net70  c=2.36876e-17
c849 446:vdd! 240:net69  c=1.00362e-16
c848 446:vdd! 286:net71  c=5.99888e-19
c847 446:vdd! 225:net69  c=3.07325e-25
c846 446:vdd! xi18|mm1|bulk  c=8.89649e-18
c845 446:vdd! 245:net69  c=6.24109e-20
c844 446:vdd! 329:ln_n_187  c=3.01213e-17
c843 446:vdd! 291:ln_n_186  c=2.74794e-18
c842 446:vdd! 289:net71  c=2.89562e-18
cg841 445:vdd! 0  c=1.43178e-17
c840 445:vdd! 288:net71  c=1.66224e-18
c839 445:vdd! 259:net71  c=6.05248e-18
c838 445:vdd! 272:net71  c=1.69034e-17
c837 445:vdd! 243:net69  c=1.32678e-18
c836 445:vdd! 256:net70  c=3.1563e-21
c835 445:vdd! 257:net70  c=1.15205e-19
c834 445:vdd! 240:net69  c=1.14876e-16
c833 445:vdd! 292:ln_n_186  c=5.94273e-18
c832 445:vdd! 224:net69  c=5.99888e-19
c831 445:vdd! 225:net69  c=1.74011e-17
c830 445:vdd! xi18|mm1|bulk  c=1.19271e-17
c829 445:vdd! 245:net69  c=3.87175e-18
c828 445:vdd! 291:ln_n_186  c=3.18766e-17
c827 445:vdd! 289:net71  c=8.54606e-19
c826 444:vdd! 258:net70  c=5.26087e-20
c825 444:vdd! 367:net75  c=7.67261e-19
c824 444:vdd! 256:net70  c=1.52988e-19
c823 444:vdd! 295:ln_n_192  c=1.74464e-18
c822 444:vdd! 337:net75  c=3.77796e-18
c821 444:vdd! xi18|mm1|bulk  c=3.66441e-18
c820 444:vdd! 344:net75  c=1.31188e-18
c819 443:vdd! 316:q  c=1.49335e-19
c818 443:vdd! 333:ln_n_193  c=1.63156e-18
c817 443:vdd! 335:ln_n_193  c=1.13055e-19
c816 443:vdd! 337:net75  c=3.89195e-18
c815 443:vdd! xi18|mm1|bulk  c=3.56314e-18
c814 443:vdd! 314:q  c=1.22693e-18
cg813 442:vdd! 0  c=2.02476e-17
c812 442:vdd! 305:q  c=4.64558e-20
c811 442:vdd! 364:net75  c=2.98643e-19
c810 442:vdd! 365:net75  c=5.54623e-19
c809 442:vdd! 334:ln_n_193  c=1.33509e-17
c808 442:vdd! 360:net75  c=8.9451e-21
c807 442:vdd! 335:ln_n_193  c=2.42601e-19
c806 442:vdd! 328:net72  c=1.90452e-17
c805 442:vdd! 367:net75  c=4.65901e-25
c804 442:vdd! 314:q  c=5.88145e-19
c803 442:vdd! 350:net75  c=5.74219e-21
c802 442:vdd! 337:net75  c=1.20073e-16
c801 442:vdd! 333:ln_n_193  c=3.04708e-17
c800 442:vdd! 295:ln_n_192  c=3.19413e-18
c799 442:vdd! 315:q  c=1.01378e-17
c798 442:vdd! 317:net72  c=1.1776e-17
c797 442:vdd! xi18|mm1|bulk  c=1.23698e-17
c796 442:vdd! 366:net75  c=7.11692e-19
cg795 441:vdd! 0  c=1.2551e-17
c794 441:vdd! 288:net71  c=7.04443e-20
c793 441:vdd! 258:net70  c=1.67013e-18
c792 441:vdd! 246:net69  c=5.58841e-25
c791 441:vdd! 244:net69  c=2.33001e-19
c790 441:vdd! 328:net72  c=8.32492e-20
c789 441:vdd! 256:net70  c=2.16101e-19
c788 441:vdd! 367:net75  c=6.40089e-18
c787 441:vdd! 344:net75  c=4.59024e-19
c786 441:vdd! 240:net69  c=5.55989e-19
c785 441:vdd! 337:net75  c=3.07148e-17
c784 441:vdd! 295:ln_n_192  c=1.11008e-17
c783 441:vdd! 239:net69  c=3.38896e-22
c782 441:vdd! 315:q  c=9.30417e-19
c781 441:vdd! 317:net72  c=2.90754e-19
c780 441:vdd! xi18|mm1|bulk  c=1.22086e-17
cg779 440:vdd! 0  c=7.18899e-18
c778 440:vdd! 245:net69  c=3.59029e-19
c777 440:vdd! 240:net69  c=2.04047e-18
c776 440:vdd! xi18|mm1|bulk  c=4.44984e-18
cg775 437:vdd! 0  c=2.17877e-18
c774 437:vdd! xi18|mm1|bulk  c=3.27429e-18
cg773 433:vdd! 0  c=8.78123e-18
c772 433:vdd! xi18|mm1|bulk  c=5.02299e-18
cg771 430:vdd! 0  c=2.63922e-19
c770 430:vdd! 288:net71  c=1.85923e-18
c769 430:vdd! 256:net70  c=1.77064e-18
c768 430:vdd! 240:net69  c=2.54424e-17
c767 430:vdd! xi18|mm1|bulk  c=1.57176e-18
cg766 429:vdd! 0  c=8.78394e-19
c765 429:vdd! 258:net70  c=2.04192e-19
c764 429:vdd! 256:net70  c=8.31813e-19
c763 429:vdd! 240:net69  c=1.02878e-18
c762 429:vdd! xi18|mm1|bulk  c=5.50639e-18
c761 429:vdd! 337:net75  c=9.77126e-18
cg760 428:vdd! 0  c=4.41127e-19
c759 428:vdd! 240:net69  c=2.57602e-17
c758 428:vdd! xi18|mm1|bulk  c=1.8164e-18
c757 427:vdd! xi18|mm1|bulk  c=3.86575e-18
cg756 423:vdd! 0  c=7.78767e-18
c755 423:vdd! xi18|mm1|bulk  c=5.46794e-18
c754 420:vdd! xi18|mm1|bulk  c=4.02894e-18
cg753 416:vdd! 0  c=7.68143e-18
c752 416:vdd! xi18|mm1|bulk  c=5.74785e-18
cg751 412:vdd! 0  c=6.67469e-18
c750 412:vdd! 367:net75  c=1.36786e-20
c749 412:vdd! 337:net75  c=3.77715e-21
c748 412:vdd! xi18|mm1|bulk  c=5.9052e-18
c747 409:vdd! xi18|mm1|bulk  c=3.97936e-18
c746 407:vdd! xi18|mm1|bulk  c=4.04439e-18
cg745 405:vdd! 0  c=7.65004e-18
c744 405:vdd! 316:q  c=1.13303e-25
c743 405:vdd! xi18|mm1|bulk  c=5.49046e-18
cg742 402:vdd! 0  c=1.94237e-18
c741 402:vdd! xi18|mm1|bulk  c=6.03054e-18
c740 402:vdd! 337:net75  c=9.19367e-18
cg739 378:vdd! 0  c=8.26878e-18
c738 378:vdd! 345:net75  c=4.58802e-20
c737 378:vdd! 367:net75  c=2.1536e-19
c736 378:vdd! 296:ln_n_192  c=1.06956e-17
c735 378:vdd! 363:net75  c=1.19184e-17
c734 378:vdd! 297:ln_n_192  c=2.09064e-19
c733 378:vdd! 348:net75  c=8.4745e-18
c732 378:vdd! 337:net75  c=8.04116e-17
c731 378:vdd! 268:net71  c=8.50228e-19
c730 378:vdd! 295:ln_n_192  c=2.00705e-17
c729 378:vdd! 315:q  c=1.57207e-17
c728 378:vdd! xi18|mm1|bulk  c=1.47088e-18
c727 378:vdd! 287:net71  c=2.92969e-20
cg726 377:vdd! 0  c=1.15711e-18
c725 377:vdd! 316:q  c=1.51326e-20
c724 377:vdd! 335:ln_n_193  c=3.49561e-20
c723 377:vdd! 337:net75  c=2.42038e-20
c722 377:vdd! xi18|mm1|bulk  c=7.61049e-18
cg721 vdd! 0  c=4.25683e-16
c720 vdd! 288:net71  c=1.80188e-17
c719 vdd! 258:net70  c=3.08186e-18
c718 vdd! 259:net71  c=1.30035e-18
c717 vdd! 244:net69  c=9.07808e-19
c716 vdd! 360:net75  c=6.87833e-21
c715 vdd! 243:net69  c=2.21251e-18
c714 vdd! 256:net70  c=1.82438e-16
c713 vdd! 367:net75  c=2.16506e-18
c712 vdd! 363:net75  c=7.62966e-18
c711 vdd! 240:net69  c=1.08834e-16
c710 vdd! 350:net75  c=1.65702e-18
c709 vdd! 337:net75  c=3.68356e-17
c708 vdd! 268:net71  c=7.13871e-18
c707 vdd! 239:net69  c=9.51271e-19
c706 vdd! 247:net69  c=2.77999e-20
c705 vdd! 315:q  c=2.71863e-18
c704 vdd! 317:net72  c=6.21732e-17
c703 vdd! xi18|mm1|bulk  c=2.77062e-16
c702 vdd! 245:net69  c=1.0812e-17
c701 vdd! 269:net71  c=4.98336e-18
c700 vdd! 291:ln_n_186  c=9.70097e-20
c699 vdd! 289:net71  c=1.45289e-18
cg698 xi15|mm2|src 0  c=1.19953e-18
c697 xi15|mm2|src 369:ln_n_183  c=5.07965e-17
cg696 xi20|mm2|src 0  c=2.93973e-18
c695 xi20|mm2|src 292:ln_n_186  c=9.48515e-18
c694 xi20|mm2|src 291:ln_n_186  c=4.65256e-17
c693 xi20|mm2|src xi16|mm0|src  c=2.81489e-17
c692 xi20|mm2|src xi20|mm2|drn  c=9.35155e-17
cg691 xi21|mm2|src 0  c=1.101e-18
c690 xi21|mm2|src 330:ln_n_187  c=9.3056e-18
c689 xi21|mm2|src 291:ln_n_186  c=1.76105e-18
c688 xi21|mm2|src 329:ln_n_187  c=4.65256e-17
c687 xi21|mm2|src xi20|mm2|drn  c=2.81489e-17
c686 xi21|mm2|src xi21|mm2|drn  c=9.35155e-17
c685 xi21|mm2|src xi17|mm0|drn  c=8.48477e-20
cg684 xi23|mm2|src 0  c=2.94047e-18
c683 xi23|mm2|src 297:ln_n_192  c=1.03711e-18
c682 xi23|mm2|src 296:ln_n_192  c=2.38506e-17
c681 xi23|mm2|src 295:ln_n_192  c=4.54863e-17
c680 xi23|mm2|src xi19|mm0|src  c=2.78847e-17
c679 xi23|mm2|src xi19|mm0|drn  c=8.48477e-20
c678 xi23|mm2|src xi23|mm2|drn  c=9.38071e-17
cg677 xi22|mm2|src 0  c=1.22702e-18
c676 xi22|mm2|src 335:ln_n_193  c=1.11703e-18
c675 xi22|mm2|src 334:ln_n_193  c=2.3817e-17
c674 xi22|mm2|src xi18|mm0|drn  c=8.48477e-20
c673 xi22|mm2|src 295:ln_n_192  c=1.71346e-18
c672 xi22|mm2|src 333:ln_n_193  c=4.55138e-17
c671 xi22|mm2|src xi23|mm2|drn  c=2.78847e-17
c670 xi22|mm2|src xi22|mm2|drn  c=9.36521e-17
cg669 376:vdd! 0  c=7.63043e-19
c668 376:vdd! 367:net75  c=4.23899e-20
c667 376:vdd! xi18|mm1|bulk  c=7.67964e-18
cg666 375:vdd! 0  c=2.96514e-18
c665 375:vdd! xi18|mm1|bulk  c=6.4999e-18
c664 374:vdd! 247:net69  c=3.75066e-24
c663 374:vdd! xi18|mm1|bulk  c=7.43923e-18
c662 373:vdd! 289:net71  c=3.60633e-20
c661 373:vdd! xi18|mm1|bulk  c=7.76952e-18
cg660 xi18|mm1|bulk 0  c=1.17331e-16
c659 xi18|mm1|bulk 205:gnd!  c=5.77114e-18
c658 xi18|mm1|bulk 294:ln_n_186  c=5.9759e-17
c657 xi18|mm1|bulk 292:ln_n_186  c=1.54901e-17
c656 xi18|mm1|bulk 204:gnd!  c=3.73928e-18
c655 xi18|mm1|bulk 293:ln_n_186  c=1.43529e-17
c654 xi18|mm1|bulk 203:gnd!  c=3.73862e-18
c653 xi18|mm1|bulk 289:net71  c=3.67769e-18
c652 xi18|mm1|bulk 243:net69  c=3.30089e-18
c651 xi18|mm1|bulk 259:net71  c=8.0542e-18
c650 xi18|mm1|bulk 57:ln_n_184  c=2.28261e-17
c649 xi18|mm1|bulk 272:net71  c=6.98321e-18
c648 xi18|mm1|bulk 58:ln_n_184  c=4.25109e-18
c647 xi18|mm1|bulk 290:net71  c=6.34296e-18
c646 xi18|mm1|bulk 271:net71  c=6.8738e-18
c645 xi18|mm1|bulk 50:ln_n_185  c=1.04737e-17
c644 xi18|mm1|bulk 51:ln_n_185  c=1.07734e-17
c643 xi18|mm1|bulk 369:ln_n_183  c=5.82593e-17
c642 xi18|mm1|bulk 195:gnd!  c=4.15816e-18
c641 xi18|mm1|bulk 213:gnd!  c=5.22675e-18
c640 xi18|mm1|bulk 372:ln_n_183  c=4.40214e-17
c639 xi18|mm1|bulk 184:gnd!  c=3.86542e-18
c638 xi18|mm1|bulk 371:ln_n_183  c=4.20994e-18
c637 xi18|mm1|bulk 182:gnd!  c=3.86594e-18
c636 xi18|mm1|bulk 207:gnd!  c=5.48205e-18
c635 xi18|mm1|bulk 206:gnd!  c=3.57314e-18
c634 xi18|mm1|bulk 317:net72  c=2.53546e-17
c633 xi18|mm1|bulk 196:gnd!  c=3.57268e-18
c632 xi18|mm1|bulk 327:net72  c=4.5592e-17
c631 xi18|mm1|bulk 366:net75  c=2.97021e-17
c630 xi18|mm1|bulk 247:net69  c=7.90907e-18
c629 xi18|mm1|bulk 364:net75  c=1.79825e-18
c628 xi18|mm1|bulk 225:net69  c=3.18817e-17
c627 xi18|mm1|bulk 365:net75  c=4.15963e-18
c626 xi18|mm1|bulk 245:net69  c=8.49557e-18
c625 xi18|mm1|bulk 328:net72  c=1.16795e-17
c624 xi18|mm1|bulk 211:gnd!  c=8.83334e-18
c623 xi18|mm1|bulk 158:gnd!  c=3.86112e-18
c622 xi18|mm1|bulk 160:gnd!  c=3.86111e-18
c621 xi18|mm1|bulk 200:gnd!  c=5.46211e-18
c620 xi18|mm1|bulk 198:gnd!  c=3.56347e-18
c619 xi18|mm1|bulk 199:gnd!  c=3.56379e-18
c618 xi18|mm1|bulk 215:gnd!  c=9.3488e-18
c617 xi18|mm1|bulk 192:gnd!  c=3.26803e-18
c616 xi18|mm1|bulk 194:gnd!  c=3.2684e-18
c615 xi18|mm1|bulk 212:gnd!  c=9.31468e-18
c614 xi18|mm1|bulk 165:gnd!  c=3.97723e-18
c613 xi18|mm1|bulk 210:gnd!  c=4.74584e-18
c612 xi18|mm1|bulk 169:gnd!  c=3.97796e-18
c611 xi18|mm1|bulk 208:gnd!  c=3.13601e-18
c610 xi18|mm1|bulk 209:gnd!  c=3.13636e-18
c609 xi18|mm1|bulk 26:ln_n_195  c=3.03934e-17
c608 xi18|mm1|bulk gnd!  c=2.93437e-16
c607 xi18|mm1|bulk 33:ln_n_194  c=9.96551e-18
c606 xi18|mm1|bulk 34:ln_n_194  c=9.26417e-18
c605 xi18|mm1|bulk 28:ln_n_195  c=3.97444e-18
c604 xi18|mm1|bulk 197:gnd!  c=3.70136e-18
c603 xi18|mm1|bulk 202:gnd!  c=5.70837e-18
c602 xi18|mm1|bulk 201:gnd!  c=3.70278e-18
c601 xi18|mm1|bulk 336:ln_n_193  c=7.16124e-17
c600 xi18|mm1|bulk 367:net75  c=5.72235e-18
c599 xi18|mm1|bulk 363:net75  c=6.47866e-18
c598 xi18|mm1|bulk 334:ln_n_193  c=1.01015e-17
c597 xi18|mm1|bulk 348:net75  c=1.97911e-18
c596 xi18|mm1|bulk 368:net75  c=6.67774e-18
c595 xi18|mm1|bulk 335:ln_n_193  c=1.65118e-17
c594 xi18|mm1|bulk 347:net75  c=3.94827e-17
c593 xi18|mm1|bulk 298:ln_n_192  c=7.38602e-17
c592 xi18|mm1|bulk 268:net71  c=3.11494e-17
c591 xi18|mm1|bulk 296:ln_n_192  c=1.07421e-17
c590 xi18|mm1|bulk 297:ln_n_192  c=1.41922e-17
c589 xi18|mm1|bulk 269:net71  c=3.61822e-18
c588 xi18|mm1|bulk 360:net75  c=5.04421e-18
c587 xi18|mm1|bulk 350:net75  c=1.13759e-18
c586 xi18|mm1|bulk 287:net71  c=4.22186e-18
c585 xi18|mm1|bulk 101:ln_n_189  c=9.31192e-18
c584 xi18|mm1|bulk 102:ln_n_189  c=1.00238e-17
c583 xi18|mm1|bulk 162:gnd!  c=5.06084e-18
c582 xi18|mm1|bulk 246:net69  c=2.73315e-17
c581 xi18|mm1|bulk 30:ln_n_190  c=1.04407e-17
c580 xi18|mm1|bulk 244:net69  c=4.78657e-18
c579 xi18|mm1|bulk 170:gnd!  c=4.62987e-18
c578 xi18|mm1|bulk 31:ln_n_190  c=1.16666e-17
c577 xi18|mm1|bulk 337:net75  c=2.48132e-17
c576 xi18|mm1|bulk 32:ln_n_194  c=1.19411e-17
c575 xi18|mm1|bulk 240:net69  c=2.0808e-17
c574 xi18|mm1|bulk 333:ln_n_193  c=1.17117e-17
c573 xi18|mm1|bulk 295:ln_n_192  c=1.22597e-17
c572 xi18|mm1|bulk 24:ln_n_188  c=9.88128e-18
c571 xi18|mm1|bulk 103:ln_n_191  c=9.57958e-18
c570 xi18|mm1|bulk 25:ln_n_188  c=1.04564e-17
c569 xi18|mm1|bulk 29:ln_n_190  c=1.02029e-17
c568 xi18|mm1|bulk 100:ln_n_189  c=1.39008e-17
c567 xi18|mm1|bulk 239:net69  c=1.33552e-18
c566 xi18|mm1|bulk 104:ln_n_191  c=1.04132e-17
c565 xi18|mm1|bulk 23:ln_n_188  c=1.20896e-17
c564 xi18|mm1|bulk 105:ln_n_191  c=1.18733e-17
c563 xi18|mm1|bulk 329:ln_n_187  c=2.18068e-17
c562 xi18|mm1|bulk 291:ln_n_186  c=2.28934e-17
c561 xi18|mm1|bulk 49:ln_n_185  c=9.34973e-18
c560 xi18|mm1|bulk 332:ln_n_187  c=6.30125e-17
c559 xi18|mm1|bulk 56:ln_n_184  c=3.25537e-17
c558 xi18|mm1|bulk 186:gnd!  c=4.70224e-18
c557 xi18|mm1|bulk 214:gnd!  c=7.99346e-18
c556 xi18|mm1|bulk 288:net71  c=2.86577e-17
c555 xi18|mm1|bulk 330:ln_n_187  c=1.78916e-17
c554 xi18|mm1|bulk 177:gnd!  c=4.02875e-18
c553 xi18|mm1|bulk 185:gnd!  c=4.2925e-18
c552 xi18|mm1|bulk 331:ln_n_187  c=1.27994e-17
c551 xi18|mm1|bulk 175:gnd!  c=4.02843e-18
cg550 372:ln_n_183 0  c=4.0785e-17
c549 372:ln_n_183 xi15|mm3|src  c=2.42476e-17
c548 372:ln_n_183 213:gnd!  c=1.86032e-19
c547 372:ln_n_183 215:gnd!  c=1.94956e-17
c546 372:ln_n_183 196:gnd!  c=6.51251e-20
c545 372:ln_n_183 208:gnd!  c=1.28122e-18
cg544 371:ln_n_183 0  c=3.6203e-18
cg543 369:ln_n_183 0  c=4.20308e-17
c542 369:ln_n_183 xi15|mm3|src  c=2.57311e-18
c541 369:ln_n_183 215:gnd!  c=1.89563e-18
c540 369:ln_n_183 208:gnd!  c=1.59932e-19
c539 368:net75 298:ln_n_192  c=1.20256e-18
c538 368:net75 296:ln_n_192  c=2.44786e-17
c537 368:net75 297:ln_n_192  c=3.02133e-17
c536 368:net75 268:net71  c=3.93997e-18
c535 368:net75 101:ln_n_189  c=4.02417e-18
c534 368:net75 295:ln_n_192  c=2.40621e-19
c533 368:net75 102:ln_n_189  c=3.95521e-20
c532 368:net75 30:ln_n_190  c=3.29845e-20
c531 368:net75 315:q  c=4.57561e-19
c530 368:net75 316:q  c=1.98628e-18
c529 368:net75 307:q  c=8.69464e-19
cg528 367:net75 0  c=2.35998e-18
c527 367:net75 288:net71  c=9.75494e-20
c526 367:net75 268:net71  c=6.21625e-19
c525 367:net75 100:ln_n_189  c=1.53405e-18
c524 367:net75 269:net71  c=8.10078e-20
c523 367:net75 287:net71  c=1.33721e-19
cg522 366:net75 0  c=2.39929e-17
c521 366:net75 28:ln_n_195  c=8.90892e-19
c520 366:net75 328:net72  c=2.15302e-17
c519 366:net75 32:ln_n_194  c=1.64801e-17
c518 366:net75 26:ln_n_195  c=3.01036e-17
c517 366:net75 327:net72  c=1.13194e-16
c516 366:net75 307:q  c=1.45133e-19
c515 366:net75 33:ln_n_194  c=3.56324e-17
c514 366:net75 34:ln_n_194  c=4.31888e-18
cg513 365:net75 0  c=9.38042e-19
c512 365:net75 328:net72  c=1.08446e-17
c511 365:net75 32:ln_n_194  c=5.05631e-18
c510 365:net75 317:net72  c=3.83792e-18
c509 365:net75 26:ln_n_195  c=2.75668e-20
c508 365:net75 327:net72  c=1.97505e-18
c507 365:net75 33:ln_n_194  c=2.70866e-18
c506 365:net75 34:ln_n_194  c=3.38244e-18
cg505 364:net75 0  c=1.62465e-18
c504 364:net75 328:net72  c=5.74245e-18
c503 364:net75 327:net72  c=2.91124e-20
c502 364:net75 317:net72  c=1.21358e-17
c501 364:net75 32:ln_n_194  c=8.2521e-19
cg500 363:net75 0  c=6.37899e-19
c499 363:net75 288:net71  c=1.94644e-19
c498 363:net75 296:ln_n_192  c=8.34752e-19
c497 363:net75 297:ln_n_192  c=3.36096e-18
c496 363:net75 268:net71  c=1.53921e-18
c495 363:net75 315:q  c=2.08407e-19
c494 363:net75 100:ln_n_189  c=8.27416e-18
c493 363:net75 269:net71  c=3.05754e-19
c492 363:net75 287:net71  c=4.49931e-18
c491 360:net75 288:net71  c=3.66461e-19
c490 360:net75 328:net72  c=2.50857e-18
c489 360:net75 327:net72  c=4.25211e-20
c488 350:net75 328:net72  c=2.65445e-19
c487 350:net75 32:ln_n_194  c=3.67244e-18
c486 350:net75 317:net72  c=1.61265e-17
c485 348:net75 288:net71  c=2.86081e-19
c484 348:net75 296:ln_n_192  c=4.03407e-19
c483 348:net75 297:ln_n_192  c=1.43975e-18
c482 348:net75 268:net71  c=1.75705e-17
c481 348:net75 101:ln_n_189  c=4.03165e-19
c480 348:net75 295:ln_n_192  c=1.56535e-18
c479 348:net75 315:q  c=9.61618e-19
c478 348:net75 100:ln_n_189  c=2.3239e-17
c477 348:net75 316:q  c=5.76348e-20
c476 348:net75 287:net71  c=1.47895e-19
c475 347:net75 298:ln_n_192  c=2.34749e-17
c474 347:net75 296:ln_n_192  c=8.98754e-20
c473 347:net75 297:ln_n_192  c=2.50469e-18
c472 347:net75 268:net71  c=7.05257e-17
c471 347:net75 101:ln_n_189  c=6.38098e-19
c470 347:net75 102:ln_n_189  c=3.5625e-19
c469 347:net75 29:ln_n_190  c=1.95728e-17
c468 347:net75 30:ln_n_190  c=6.74585e-18
c467 347:net75 31:ln_n_190  c=2.68062e-19
c466 347:net75 316:q  c=5.76348e-20
c465 347:net75 307:q  c=1.01455e-17
c464 345:net75 316:q  c=2.62315e-20
c463 345:net75 296:ln_n_192  c=3.26451e-19
c462 345:net75 29:ln_n_190  c=5.29579e-19
c461 345:net75 307:q  c=5.60285e-18
c460 345:net75 295:ln_n_192  c=5.15392e-20
c459 344:net75 315:q  c=7.92899e-18
c458 xi19|mm1|src 298:ln_n_192  c=1.09224e-18
c457 xi19|mm1|src 29:ln_n_190  c=3.6601e-17
c456 xi19|mm1|src xi19|mm1|drn  c=4.82671e-17
c455 xi19|mm1|src xi23|mm3|drn  c=4.12772e-20
c454 xi19|mm0|src 297:ln_n_192  c=1.13905e-18
c453 xi19|mm0|src 100:ln_n_189  c=7.09095e-17
c452 xi19|mm0|src xi19|mm0|drn  c=9.36483e-17
c451 xi19|mm0|src 295:ln_n_192  c=1.71346e-18
c450 xi19|mm0|src xi23|mm2|drn  c=8.48477e-20
c449 xi18|mm1|drn 28:ln_n_195  c=4.99226e-18
c448 xi18|mm1|drn 33:ln_n_194  c=8.72107e-19
c447 xi18|mm1|drn 26:ln_n_195  c=4.32119e-17
c446 xi18|mm1|drn xi18|mm1|src  c=4.87054e-17
c445 xi18|mm1|drn xi22|mm3|drn  c=1.3233e-17
c444 xi18|mm0|drn xi22|mm2|drn  c=2.81489e-17
c443 xi18|mm0|drn 32:ln_n_194  c=4.65113e-17
c442 xi18|mm0|drn 317:net72  c=2.856e-18
c441 xi18|mm0|drn 33:ln_n_194  c=2.39042e-17
c440 xi18|mm0|drn xi18|mm0|src  c=9.35155e-17
c439 xi18|mm0|drn 34:ln_n_194  c=3.1845e-19
c438 337:net75 288:net71  c=7.55736e-18
c437 337:net75 328:net72  c=1.09966e-16
c436 337:net75 268:net71  c=7.54414e-19
c435 337:net75 315:q  c=1.11968e-16
c434 337:net75 317:net72  c=1.59901e-17
c433 337:net75 316:q  c=1.10796e-17
c432 337:net75 327:net72  c=1.72896e-19
c431 337:net75 269:net71  c=5.28024e-20
c430 337:net75 287:net71  c=3.11226e-19
cg429 336:ln_n_193 0  c=4.10031e-17
c428 336:ln_n_193 328:net72  c=1.39037e-16
c427 336:ln_n_193 298:ln_n_192  c=1.46177e-17
c426 336:ln_n_193 211:gnd!  c=1.75822e-17
c425 336:ln_n_193 xi22|mm3|src  c=2.42357e-17
c424 336:ln_n_193 xi22|mm3|drn  c=3.19633e-17
c423 336:ln_n_193 xi23|mm3|drn  c=9.32997e-19
c422 336:ln_n_193 316:q  c=1.19717e-18
c421 336:ln_n_193 307:q  c=1.87216e-17
cg420 335:ln_n_193 0  c=4.51576e-18
c419 335:ln_n_193 xi23|mm2|drn  c=1.05602e-18
c418 335:ln_n_193 328:net72  c=2.73742e-19
c417 335:ln_n_193 298:ln_n_192  c=2.19379e-18
c416 335:ln_n_193 297:ln_n_192  c=1.01704e-19
c415 335:ln_n_193 198:gnd!  c=9.42172e-20
c414 335:ln_n_193 295:ln_n_192  c=1.28558e-18
c413 335:ln_n_193 315:q  c=1.3715e-18
c412 335:ln_n_193 316:q  c=3.07122e-17
c411 335:ln_n_193 307:q  c=1.75223e-18
cg410 334:ln_n_193 0  c=7.01562e-18
c409 334:ln_n_193 305:q  c=3.27182e-19
c408 334:ln_n_193 328:net72  c=3.10339e-18
c407 334:ln_n_193 296:ln_n_192  c=3.26724e-18
c406 334:ln_n_193 211:gnd!  c=6.62847e-19
c405 334:ln_n_193 xi22|mm3|src  c=2.1496e-18
c404 334:ln_n_193 315:q  c=3.84466e-19
c403 334:ln_n_193 316:q  c=2.46538e-17
c402 334:ln_n_193 307:q  c=8.57856e-20
cg401 333:ln_n_193 0  c=1.06146e-17
c400 333:ln_n_193 xi22|mm2|drn  c=7.19136e-17
c399 333:ln_n_193 xi23|mm2|drn  c=1.71346e-18
c398 333:ln_n_193 305:q  c=5.18071e-20
c397 333:ln_n_193 328:net72  c=4.2571e-17
c396 333:ln_n_193 295:ln_n_192  c=1.96187e-18
c395 333:ln_n_193 315:q  c=2.01883e-18
c394 333:ln_n_193 317:net72  c=1.12697e-18
c393 333:ln_n_193 316:q  c=2.44082e-19
cg392 332:ln_n_187 0  c=3.49265e-17
c391 332:ln_n_187 xi20|mm3|drn  c=9.38245e-19
c390 332:ln_n_187 290:net71  c=8.36582e-19
c389 332:ln_n_187 271:net71  c=1.37307e-17
c388 332:ln_n_187 197:gnd!  c=1.39553e-19
c387 332:ln_n_187 257:net70  c=1.14302e-16
c386 332:ln_n_187 294:ln_n_186  c=1.19022e-17
c385 332:ln_n_187 292:ln_n_186  c=3.62614e-21
c384 332:ln_n_187 214:gnd!  c=1.85545e-17
c383 332:ln_n_187 293:ln_n_186  c=2.03236e-21
c382 332:ln_n_187 xi21|mm3|src  c=2.42243e-17
c381 332:ln_n_187 203:gnd!  c=1.92329e-18
c380 332:ln_n_187 xi21|mm3|drn  c=3.65885e-17
c379 332:ln_n_187 212:gnd!  c=3.1137e-20
cg378 331:ln_n_187 0  c=3.01441e-18
c377 331:ln_n_187 259:net71  c=2.03638e-18
c376 331:ln_n_187 272:net71  c=1.22594e-18
c375 331:ln_n_187 290:net71  c=2.08433e-17
c374 331:ln_n_187 271:net71  c=6.49995e-19
c373 331:ln_n_187 257:net70  c=2.20899e-19
c372 331:ln_n_187 294:ln_n_186  c=7.53111e-19
c371 331:ln_n_187 292:ln_n_186  c=1.35804e-19
c370 331:ln_n_187 293:ln_n_186  c=6.93708e-20
c369 331:ln_n_187 203:gnd!  c=1.95183e-19
c368 331:ln_n_187 291:ln_n_186  c=1.256e-18
cg367 330:ln_n_187 0  c=6.48401e-18
c366 330:ln_n_187 259:net71  c=2.44763e-20
c365 330:ln_n_187 272:net71  c=4.79061e-19
c364 330:ln_n_187 290:net71  c=3.04568e-17
c363 330:ln_n_187 271:net71  c=6.74762e-19
c362 330:ln_n_187 265:net71  c=3.80374e-19
c361 330:ln_n_187 257:net70  c=7.46694e-18
c360 330:ln_n_187 292:ln_n_186  c=4.08993e-18
c359 330:ln_n_187 214:gnd!  c=1.38428e-18
c358 330:ln_n_187 xi21|mm3|src  c=2.48678e-18
cg357 329:ln_n_187 0  c=1.72281e-17
c356 329:ln_n_187 259:net71  c=1.77268e-18
c355 329:ln_n_187 272:net71  c=4.75133e-18
c354 329:ln_n_187 290:net71  c=9.5973e-19
c353 329:ln_n_187 265:net71  c=6.58938e-20
c352 329:ln_n_187 xi21|mm2|drn  c=7.19279e-17
c351 329:ln_n_187 256:net70  c=4.20225e-19
c350 329:ln_n_187 xi20|mm2|drn  c=1.76105e-18
c349 329:ln_n_187 257:net70  c=6.03158e-17
c348 329:ln_n_187 291:ln_n_186  c=4.07533e-18
c347 329:ln_n_187 289:net71  c=7.30655e-19
cg346 328:net72 0  c=5.4944e-17
c345 328:net72 28:ln_n_195  c=8.4927e-19
c344 328:net72 211:gnd!  c=8.98245e-18
c343 328:net72 32:ln_n_194  c=2.20076e-18
c342 328:net72 gnd!  c=9.31176e-18
c341 328:net72 33:ln_n_194  c=2.54539e-18
c340 328:net72 34:ln_n_194  c=3.22093e-18
cg339 327:net72 0  c=7.22149e-17
c338 327:net72 32:ln_n_194  c=2.79099e-17
c337 327:net72 gnd!  c=1.77438e-17
c336 327:net72 26:ln_n_195  c=2.52325e-17
c335 327:net72 33:ln_n_194  c=7.27278e-18
c334 327:net72 34:ln_n_194  c=5.74138e-19
cg333 317:net72 0  c=1.71114e-17
c332 317:net72 32:ln_n_194  c=2.99373e-17
c331 317:net72 gnd!  c=4.0703e-19
c330 317:net72 26:ln_n_195  c=4.26994e-20
c329 xi18|mm1|src 26:ln_n_195  c=3.65653e-17
c328 xi18|mm0|src 32:ln_n_194  c=7.18054e-17
cg327 xi22|mm3|drn 0  c=4.35704e-20
c326 xi22|mm3|drn 28:ln_n_195  c=4.95218e-18
c325 xi22|mm3|drn 26:ln_n_195  c=7.12355e-19
c324 xi22|mm3|drn xi22|mm3|src  c=4.86361e-17
cg323 xi22|mm2|drn 0  c=8.48477e-20
c322 xi22|mm2|drn 34:ln_n_194  c=3.17584e-19
c321 xi22|mm2|drn 32:ln_n_194  c=1.76105e-18
cg320 316:q 0  c=7.38522e-18
c319 316:q 298:ln_n_192  c=2.97763e-19
c318 316:q 296:ln_n_192  c=2.78621e-18
c317 316:q 297:ln_n_192  c=2.9375e-20
c316 316:q 198:gnd!  c=3.1505e-19
c315 316:q 199:gnd!  c=1.42976e-24
cg314 315:q 0  c=2.42464e-17
c313 315:q 296:ln_n_192  c=3.0573e-19
c312 315:q 297:ln_n_192  c=7.78103e-20
c311 315:q 295:ln_n_192  c=3.39127e-17
cg310 314:q 0  c=1.17797e-17
cg309 307:q 0  c=4.58895e-17
c308 307:q 298:ln_n_192  c=1.37765e-16
c307 307:q 211:gnd!  c=6.06594e-18
c306 307:q 297:ln_n_192  c=1.68589e-19
c305 307:q gnd!  c=1.14689e-17
c304 307:q 212:gnd!  c=9.13908e-18
cg303 305:q 0  c=6.98757e-18
c302 305:q 298:ln_n_192  c=5.29579e-19
c301 305:q 211:gnd!  c=4.14047e-18
c300 305:q 200:gnd!  c=2.33772e-20
c299 305:q 198:gnd!  c=1.75358e-18
cg298 xi23|mm3|drn 0  c=4.91624e-20
c297 xi23|mm3|drn 298:ln_n_192  c=3.65912e-17
c296 xi23|mm3|drn xi23|mm3|src  c=4.80215e-17
c295 xi23|mm3|drn xi22|mm3|src  c=1.44548e-17
cg294 xi23|mm2|drn 0  c=8.48477e-20
c293 xi23|mm2|drn 295:ln_n_192  c=7.08841e-17
cg292 298:ln_n_192 0  c=2.09267e-17
c291 298:ln_n_192 211:gnd!  c=2.48799e-18
c290 298:ln_n_192 xi22|mm3|src  c=9.22364e-19
c289 298:ln_n_192 xi23|mm3|src  c=2.42243e-17
c288 298:ln_n_192 212:gnd!  c=1.99111e-17
cg287 297:ln_n_192 0  c=6.00485e-18
c286 297:ln_n_192 197:gnd!  c=4.71086e-20
c285 297:ln_n_192 201:gnd!  c=1.57029e-20
cg284 296:ln_n_192 0  c=6.47517e-18
c283 296:ln_n_192 197:gnd!  c=1.19706e-20
c282 296:ln_n_192 xi23|mm3|src  c=2.17903e-18
c281 296:ln_n_192 212:gnd!  c=6.87371e-19
cg280 295:ln_n_192 0  c=4.58708e-18
cg279 294:ln_n_186 0  c=1.6411e-17
c278 294:ln_n_186 xi20|mm3|src  c=2.42243e-17
c277 294:ln_n_186 xi20|mm3|drn  c=3.65912e-17
c276 294:ln_n_186 xi16|mm1|src  c=9.72165e-19
c275 294:ln_n_186 271:net71  c=1.03548e-16
c274 294:ln_n_186 213:gnd!  c=1.89964e-17
c273 294:ln_n_186 265:net71  c=5.29579e-19
c272 294:ln_n_186 196:gnd!  c=1.48003e-18
c271 294:ln_n_186 214:gnd!  c=2.19693e-18
c270 294:ln_n_186 247:net69  c=3.28393e-19
c269 294:ln_n_186 225:net69  c=7.13033e-18
c268 294:ln_n_186 xi21|mm3|src  c=9.38245e-19
c267 294:ln_n_186 203:gnd!  c=2.66874e-19
cg266 293:ln_n_186 0  c=5.20729e-18
c265 293:ln_n_186 272:net71  c=1.03953e-19
c264 293:ln_n_186 271:net71  c=1.03953e-19
c263 293:ln_n_186 247:net69  c=1.94678e-17
c262 293:ln_n_186 225:net69  c=1.88406e-18
cg261 292:ln_n_186 0  c=7.45484e-18
c260 292:ln_n_186 xi20|mm3|src  c=1.38952e-18
c259 292:ln_n_186 272:net71  c=4.46916e-19
c258 292:ln_n_186 290:net71  c=3.054e-18
c257 292:ln_n_186 271:net71  c=1.31409e-18
c256 292:ln_n_186 221:net69  c=1.97959e-19
c255 292:ln_n_186 247:net69  c=3.08882e-17
c254 292:ln_n_186 225:net69  c=1.44706e-18
cg253 291:ln_n_186 0  c=7.46505e-18
c252 291:ln_n_186 259:net71  c=8.8243e-18
c251 291:ln_n_186 272:net71  c=4.38316e-17
c250 291:ln_n_186 xi20|mm2|drn  c=7.19279e-17
c249 291:ln_n_186 xi16|mm0|src  c=1.76105e-18
c248 291:ln_n_186 240:net69  c=3.16323e-19
c247 291:ln_n_186 221:net69  c=2.44138e-20
c246 291:ln_n_186 247:net69  c=8.77631e-19
c245 291:ln_n_186 225:net69  c=6.38457e-18
c244 291:ln_n_186 245:net69  c=8.94136e-21
c243 291:ln_n_186 289:net71  c=1.63259e-18
c242 290:net71 257:net70  c=2.63002e-18
c241 290:net71 221:net69  c=3.30943e-20
c240 290:net71 247:net69  c=1.97363e-18
c239 290:net71 225:net69  c=1.63292e-19
c238 290:net71 204:gnd!  c=1.66805e-24
c237 290:net71 203:gnd!  c=3.00679e-19
cg236 289:net71 0  c=1.59105e-18
c235 289:net71 257:net70  c=1.54835e-19
c234 289:net71 240:net69  c=1.01687e-17
c233 289:net71 225:net69  c=3.94316e-20
c232 288:net71 258:net70  c=1.17756e-16
c231 288:net71 246:net69  c=1.13098e-16
c230 288:net71 244:net69  c=6.51788e-18
c229 288:net71 243:net69  c=1.04157e-18
c228 288:net71 256:net70  c=7.08605e-18
c227 288:net71 257:net70  c=1.20459e-16
c226 288:net71 240:net69  c=6.75272e-17
c225 288:net71 239:net69  c=2.28304e-17
c224 288:net71 225:net69  c=7.11685e-21
cg223 287:net71 0  c=1.30841e-18
c222 287:net71 258:net70  c=1.07901e-17
c221 287:net71 246:net69  c=5.54339e-19
c220 287:net71 101:ln_n_189  c=8.11695e-19
c219 287:net71 102:ln_n_189  c=3.74239e-18
c218 287:net71 100:ln_n_189  c=5.03717e-18
cg217 286:net71 0  c=1.05916e-18
c216 286:net71 257:net70  c=1.05494e-17
c215 286:net71 256:net70  c=2.73376e-19
cg214 272:net71 0  c=3.56347e-19
c213 272:net71 257:net70  c=3.69461e-18
c212 272:net71 224:net69  c=5.66667e-18
c211 272:net71 247:net69  c=8.48881e-19
c210 272:net71 225:net69  c=4.04221e-18
cg209 271:net71 0  c=5.89313e-18
c208 271:net71 246:net69  c=3.38057e-24
c207 271:net71 213:gnd!  c=1.02213e-17
c206 271:net71 257:net70  c=2.7622e-18
c205 271:net71 221:net69  c=5.55555e-18
c204 271:net71 214:gnd!  c=6.4072e-18
c203 271:net71 gnd!  c=1.24375e-17
c202 271:net71 247:net69  c=2.07315e-19
c201 271:net71 225:net69  c=1.95822e-18
c200 269:net71 246:net69  c=3.12864e-19
c199 269:net71 258:net70  c=6.01542e-18
c198 269:net71 100:ln_n_189  c=9.02259e-19
c197 268:net71 258:net70  c=2.29224e-17
c196 268:net71 246:net69  c=1.77873e-18
c195 268:net71 101:ln_n_189  c=3.69006e-17
c194 268:net71 102:ln_n_189  c=4.32508e-18
c193 268:net71 gnd!  c=1.16109e-17
c192 268:net71 29:ln_n_190  c=1.25249e-17
c191 268:net71 30:ln_n_190  c=3.61891e-17
c190 268:net71 100:ln_n_189  c=2.01602e-17
c189 268:net71 31:ln_n_190  c=3.76529e-18
c188 268:net71 212:gnd!  c=6.10761e-19
c187 xi20|mm3|drn xi20|mm3|src  c=4.80215e-17
c186 xi20|mm3|drn xi21|mm3|src  c=1.44548e-17
c185 xi20|mm3|drn xi16|mm1|src  c=4.35704e-20
c184 xi20|mm3|drn xi17|mm1|drn  c=6.27422e-21
c183 xi20|mm3|drn xi21|mm3|drn  c=4.35704e-20
c182 xi20|mm2|drn xi16|mm0|src  c=8.48477e-20
c181 xi20|mm2|drn xi21|mm2|drn  c=8.48477e-20
c180 xi19|mm1|drn 31:ln_n_190  c=1.84667e-18
c179 xi19|mm1|drn 30:ln_n_190  c=2.34675e-17
c178 xi19|mm1|drn 29:ln_n_190  c=2.24605e-17
c177 xi19|mm1|drn xi21|mm3|src  c=4.37988e-22
c176 xi19|mm1|drn xi23|mm3|src  c=4.12772e-20
c175 xi19|mm1|drn xi17|mm1|drn  c=4.12772e-20
c174 xi19|mm1|drn xi21|mm3|drn  c=5.1152e-20
c173 xi19|mm1|drn xi17|mm1|src  c=1.32317e-17
c172 xi19|mm0|drn 102:ln_n_189  c=1.19583e-19
c171 xi19|mm0|drn 101:ln_n_189  c=2.39071e-17
c170 xi19|mm0|drn 100:ln_n_189  c=4.65185e-17
c169 xi19|mm0|drn xi17|mm0|drn  c=8.48477e-20
c168 xi19|mm0|drn xi17|mm0|src  c=2.81489e-17
c167 265:net71 257:net70  c=5.76976e-18
c166 265:net71 214:gnd!  c=3.99354e-18
c165 265:net71 205:gnd!  c=5.00214e-20
c164 265:net71 204:gnd!  c=4.33214e-20
c163 265:net71 203:gnd!  c=1.97305e-18
c162 259:net71 257:net70  c=8.37449e-19
c161 259:net71 240:net69  c=1.31592e-17
c160 259:net71 224:net69  c=2.55759e-18
c159 259:net71 225:net69  c=2.76365e-19
cg158 258:net70 0  c=5.48149e-17
c157 258:net70 24:ln_n_188  c=5.14613e-18
c156 258:net70 246:net69  c=7.98297e-17
c155 258:net70 25:ln_n_188  c=3.81705e-19
c154 258:net70 244:net69  c=1.09153e-17
c153 258:net70 104:ln_n_191  c=4.91524e-18
c152 258:net70 105:ln_n_191  c=1.11392e-19
c151 258:net70 240:net69  c=6.72591e-18
c150 258:net70 101:ln_n_189  c=2.54539e-18
c149 258:net70 102:ln_n_189  c=4.31578e-18
c148 258:net70 103:ln_n_191  c=1.83556e-17
c147 258:net70 239:net69  c=1.07501e-18
c146 258:net70 gnd!  c=1.13122e-17
c145 258:net70 29:ln_n_190  c=1.00545e-18
c144 258:net70 30:ln_n_190  c=2.45959e-18
c143 258:net70 100:ln_n_189  c=2.94072e-18
c142 258:net70 31:ln_n_190  c=3.46564e-18
c141 258:net70 23:ln_n_188  c=4.3958e-17
cg140 257:net70 0  c=3.27513e-17
c139 257:net70 24:ln_n_188  c=2.51571e-18
c138 257:net70 246:net69  c=1.95945e-17
c137 257:net70 25:ln_n_188  c=3.19431e-18
c136 257:net70 244:net69  c=3.63029e-18
c135 257:net70 104:ln_n_191  c=2.5498e-18
c134 257:net70 105:ln_n_191  c=3.18927e-18
c133 257:net70 213:gnd!  c=3.95109e-21
c132 257:net70 240:net69  c=9.80707e-17
c131 257:net70 214:gnd!  c=1.0118e-17
c130 257:net70 103:ln_n_191  c=1.48712e-18
c129 257:net70 239:net69  c=7.64243e-19
c128 257:net70 gnd!  c=1.21622e-17
c127 257:net70 29:ln_n_190  c=4.97609e-20
c126 257:net70 23:ln_n_188  c=2.05694e-18
c125 257:net70 212:gnd!  c=4.7652e-20
cg124 256:net70 0  c=2.92887e-17
c123 256:net70 24:ln_n_188  c=3.02096e-19
c122 256:net70 246:net69  c=6.46079e-19
c121 256:net70 25:ln_n_188  c=7.82636e-19
c120 256:net70 244:net69  c=3.38951e-17
c119 256:net70 240:net69  c=4.38303e-17
c118 256:net70 23:ln_n_188  c=1.25965e-18
cg117 xi21|mm3|drn 0  c=4.37988e-22
c116 xi21|mm3|drn 105:ln_n_191  c=1.63121e-19
c115 xi21|mm3|drn 29:ln_n_190  c=4.39496e-20
c114 xi21|mm3|drn 103:ln_n_191  c=1.44144e-18
c113 xi21|mm3|drn xi21|mm3|src  c=4.80215e-17
c112 xi21|mm3|drn xi17|mm1|drn  c=1.29003e-17
c111 xi21|mm2|drn 23:ln_n_188  c=1.76105e-18
c110 xi21|mm2|drn xi17|mm0|drn  c=2.81489e-17
cg109 xi17|mm1|src 0  c=4.17152e-20
c108 xi17|mm1|src 31:ln_n_190  c=3.10459e-18
c107 xi17|mm1|src 29:ln_n_190  c=8.29043e-19
c106 xi17|mm1|src 103:ln_n_191  c=3.37555e-17
c105 xi17|mm1|src xi23|mm3|src  c=5.09802e-20
c104 xi17|mm1|src xi17|mm1|drn  c=4.87394e-17
cg103 xi17|mm0|src 0  c=8.48477e-20
c102 xi17|mm0|src 102:ln_n_189  c=1.59225e-19
c101 xi17|mm0|src 23:ln_n_188  c=7.19207e-17
c100 xi17|mm0|src 100:ln_n_189  c=1.76105e-18
c99 xi17|mm0|src xi17|mm0|drn  c=9.35155e-17
c98 247:net69 56:ln_n_184  c=4.90215e-18
c97 247:net69 50:ln_n_185  c=4.44493e-20
cg96 246:net69 0  c=1.07048e-17
c95 246:net69 24:ln_n_188  c=3.3909e-17
c94 246:net69 25:ln_n_188  c=4.45691e-18
c93 246:net69 104:ln_n_191  c=3.70637e-17
c92 246:net69 105:ln_n_191  c=3.50475e-18
c91 246:net69 103:ln_n_191  c=1.22314e-17
c90 246:net69 23:ln_n_188  c=2.84957e-17
cg89 245:net69 0  c=2.98194e-18
c88 245:net69 56:ln_n_184  c=9.55147e-18
c87 245:net69 50:ln_n_185  c=2.00846e-19
c86 244:net69 24:ln_n_188  c=1.03272e-18
c85 244:net69 25:ln_n_188  c=1.52347e-19
c84 244:net69 23:ln_n_188  c=6.94827e-18
cg83 239:net69 0  c=1.98828e-19
cg82 225:net69 0  c=3.40765e-17
c81 225:net69 56:ln_n_184  c=6.99945e-17
c80 225:net69 57:ln_n_184  c=1.10797e-17
c79 225:net69 58:ln_n_184  c=3.85481e-19
c78 225:net69 50:ln_n_185  c=7.14343e-18
c77 225:net69 51:ln_n_185  c=1.87923e-19
c76 225:net69 49:ln_n_185  c=1.98814e-17
c75 xi16|mm1|src 57:ln_n_184  c=1.73881e-21
c74 xi16|mm1|src 49:ln_n_185  c=3.6601e-17
c73 xi16|mm0|src 50:ln_n_185  c=1.1381e-21
c72 xi16|mm0|src 56:ln_n_184  c=7.19279e-17
c71 xi17|mm1|drn 105:ln_n_191  c=2.54077e-18
c70 xi17|mm1|drn 104:ln_n_191  c=2.34675e-17
c69 xi17|mm1|drn 103:ln_n_191  c=2.19118e-17
c68 xi17|mm0|drn 24:ln_n_188  c=2.3936e-17
c67 xi17|mm0|drn 23:ln_n_188  c=4.65256e-17
c66 221:net69 51:ln_n_185  c=1.50601e-23
c65 221:net69 49:ln_n_185  c=5.29579e-19
cg64 215:gnd! 0  c=1.98617e-17
cg63 214:gnd! 0  c=9.48526e-18
cg62 213:gnd! 0  c=2.02126e-17
cg61 212:gnd! 0  c=2.40586e-17
cg60 211:gnd! 0  c=1.19881e-17
cg59 210:gnd! 0  c=1.00258e-17
cg58 209:gnd! 0  c=1.70116e-18
cg57 208:gnd! 0  c=4.51856e-18
cg56 207:gnd! 0  c=7.68593e-18
cg55 206:gnd! 0  c=3.9451e-19
cg54 205:gnd! 0  c=7.44285e-18
cg53 204:gnd! 0  c=2.89688e-19
cg52 203:gnd! 0  c=2.42057e-19
cg51 202:gnd! 0  c=7.50619e-18
cg50 201:gnd! 0  c=3.43286e-19
cg49 200:gnd! 0  c=7.87903e-18
cg48 199:gnd! 0  c=4.80296e-19
cg47 198:gnd! 0  c=4.63157e-19
cg46 197:gnd! 0  c=2.52954e-18
cg45 196:gnd! 0  c=2.45081e-18
cg44 195:gnd! 0  c=5.55187e-18
cg43 194:gnd! 0  c=2.15286e-18
cg42 192:gnd! 0  c=2.15285e-18
cg41 186:gnd! 0  c=1.99063e-18
cg40 185:gnd! 0  c=8.30881e-19
cg39 184:gnd! 0  c=4.79144e-19
cg38 182:gnd! 0  c=4.79175e-19
cg37 177:gnd! 0  c=3.849e-19
cg36 175:gnd! 0  c=3.84842e-19
cg35 170:gnd! 0  c=2.03035e-18
cg34 169:gnd! 0  c=4.35454e-19
cg33 165:gnd! 0  c=4.35381e-19
cg32 162:gnd! 0  c=2.78363e-18
cg31 160:gnd! 0  c=6.4935e-19
cg30 158:gnd! 0  c=6.4935e-19
cg29 gnd! 0  c=5.02336e-16
cg28 xi15|mm3|src 0  c=1.15826e-18
cg27 xi20|mm3|src 0  c=1.65745e-17
cg26 xi21|mm3|src 0  c=1.14943e-18
cg25 xi23|mm3|src 0  c=1.60362e-17
cg24 xi22|mm3|src 0  c=1.27336e-18
cg23 105:ln_n_191 0  c=8.19564e-18
cg22 104:ln_n_191 0  c=2.04543e-17
cg21 103:ln_n_191 0  c=1.28098e-17
cg20 102:ln_n_189 0  c=5.25277e-18
cg19 101:ln_n_189 0  c=1.46871e-17
cg18 100:ln_n_189 0  c=1.39339e-17
cg17 58:ln_n_184 0  c=7.33253e-18
cg16 57:ln_n_184 0  c=2.92327e-17
cg15 56:ln_n_184 0  c=3.29062e-17
cg14 51:ln_n_185 0  c=1.00222e-17
cg13 50:ln_n_185 0  c=1.85214e-17
cg12 49:ln_n_185 0  c=1.12737e-17
cg11 34:ln_n_194 0  c=6.45243e-18
cg10 33:ln_n_194 0  c=1.38177e-17
cg9 32:ln_n_194 0  c=1.03356e-17
cg8 31:ln_n_190 0  c=6.77913e-18
cg7 30:ln_n_190 0  c=1.35595e-17
cg6 29:ln_n_190 0  c=1.1635e-17
cg5 28:ln_n_195 0  c=5.23933e-18
cg4 26:ln_n_195 0  c=2.1977e-17
cg3 25:ln_n_188 0  c=6.89917e-18
cg2 24:ln_n_188 0  c=1.39525e-17
cg1 23:ln_n_188 0  c=1.2481e-17
mxi23|mm2 xi23|mm2|drn xi23|mm2|gate xi23|mm2|src xi23|mm2|bulk P w=0.72u l=0.1u
+  nf=1 m=1 ad=0.158p as=0.158p pd=1.88u ps=1.88u nrd=1.15789 nrs=1.15789 sa=0.22u
+  sb=0.22u sd=0u
mxi22|mm2 xi22|mm2|drn xi22|mm2|gate xi22|mm2|src xi22|mm2|bulk P w=0.72u l=0.1u
+  nf=1 m=1 ad=0.158p as=0.158p pd=1.88u ps=1.88u nrd=1.15789 nrs=1.15789 sa=0.22u
+  sb=0.22u sd=0u
mxi21|mm2 xi21|mm2|drn xi21|mm2|gate xi21|mm2|src xi21|mm2|bulk P w=0.72u l=0.1u
+  nf=1 m=1 ad=0.158p as=0.158p pd=1.88u ps=1.88u nrd=1.15789 nrs=1.15789 sa=0.22u
+  sb=0.22u sd=0u
mxi20|mm2 xi20|mm2|drn xi20|mm2|gate xi20|mm2|src xi20|mm2|bulk P w=0.72u l=0.1u
+  nf=1 m=1 ad=0.158p as=0.158p pd=1.88u ps=1.88u nrd=1.15789 nrs=1.15789 sa=0.22u
+  sb=0.22u sd=0u
mxi19|mm0 xi19|mm0|drn xi19|mm0|gate xi19|mm0|src xi19|mm0|bulk P w=0.72u l=0.1u
+  nf=1 m=1 ad=0.158p as=0.158p pd=1.88u ps=1.88u nrd=1.15789 nrs=1.15789 sa=0.22u
+  sb=0.22u sd=0u
mxi18|mm0 xi18|mm0|drn xi18|mm0|gate xi18|mm0|src xi18|mm0|bulk P w=0.72u l=0.1u
+  nf=1 m=1 ad=0.158p as=0.158p pd=1.88u ps=1.88u nrd=1.15789 nrs=1.15789 sa=0.22u
+  sb=0.22u sd=0u
mxi17|mm0 xi17|mm0|drn xi17|mm0|gate xi17|mm0|src xi17|mm0|bulk P w=0.72u l=0.1u
+  nf=1 m=1 ad=0.158p as=0.158p pd=1.88u ps=1.88u nrd=1.15789 nrs=1.15789 sa=0.22u
+  sb=0.22u sd=0u
mxi16|mm0 xi16|mm0|drn xi16|mm0|gate xi16|mm0|src xi16|mm0|bulk P w=0.72u l=0.1u
+  nf=1 m=1 ad=0.158p as=0.158p pd=1.88u ps=1.88u nrd=1.15789 nrs=1.15789 sa=0.22u
+  sb=0.22u sd=0u
mxi15|mm2 xi15|mm2|drn xi15|mm2|gate xi15|mm2|src xi15|mm2|bulk P w=0.72u l=0.1u
+  nf=1 m=1 ad=0.158p as=0.158p pd=1.88u ps=1.88u nrd=1.15789 nrs=1.15789 sa=0.22u
+  sb=0.22u sd=0u
mxi23|mm3 xi23|mm3|drn xi23|mm3|gate xi23|mm3|src xi23|mm3|bulk N w=0.36u l=0.1u
+  nf=1 m=1 ad=0.079p as=0.079p pd=1.16u ps=1.16u nrd=1.15789 nrs=1.15789 sa=0.22u
+  sb=0.22u sd=0u
mxi22|mm3 xi22|mm3|drn xi22|mm3|gate xi22|mm3|src xi22|mm3|bulk N w=0.36u l=0.1u
+  nf=1 m=1 ad=0.079p as=0.079p pd=1.16u ps=1.16u nrd=1.15789 nrs=1.15789 sa=0.22u
+  sb=0.22u sd=0u
mxi21|mm3 xi21|mm3|drn xi21|mm3|gate xi21|mm3|src xi21|mm3|bulk N w=0.36u l=0.1u
+  nf=1 m=1 ad=0.079p as=0.079p pd=1.16u ps=1.16u nrd=1.15789 nrs=1.15789 sa=0.22u
+  sb=0.22u sd=0u
mxi20|mm3 xi20|mm3|drn xi20|mm3|gate xi20|mm3|src xi20|mm3|bulk N w=0.36u l=0.1u
+  nf=1 m=1 ad=0.079p as=0.079p pd=1.16u ps=1.16u nrd=1.15789 nrs=1.15789 sa=0.22u
+  sb=0.22u sd=0u
mxi19|mm1 xi19|mm1|drn xi19|mm1|gate xi19|mm1|src xi19|mm1|bulk N w=0.36u l=0.1u
+  nf=1 m=1 ad=0.079p as=0.079p pd=1.16u ps=1.16u nrd=1.15789 nrs=1.15789 sa=0.22u
+  sb=0.22u sd=0u
mxi18|mm1 xi18|mm1|drn xi18|mm1|gate xi18|mm1|src xi18|mm1|bulk N w=0.36u l=0.1u
+  nf=1 m=1 ad=0.079p as=0.079p pd=1.16u ps=1.16u nrd=1.15789 nrs=1.15789 sa=0.22u
+  sb=0.22u sd=0u
mxi17|mm1 xi17|mm1|drn xi17|mm1|gate xi17|mm1|src xi17|mm1|bulk N w=0.36u l=0.1u
+  nf=1 m=1 ad=0.079p as=0.079p pd=1.16u ps=1.16u nrd=1.15789 nrs=1.15789 sa=0.22u
+  sb=0.22u sd=0u
mxi16|mm1 xi16|mm1|drn xi16|mm1|gate xi16|mm1|src xi16|mm1|bulk N w=0.36u l=0.1u
+  nf=1 m=1 ad=0.079p as=0.079p pd=1.16u ps=1.16u nrd=1.15789 nrs=1.15789 sa=0.22u
+  sb=0.22u sd=0u
mxi15|mm3 xi15|mm3|drn xi15|mm3|gate xi15|mm3|src xi15|mm3|bulk N w=0.36u l=0.1u
+  nf=1 m=1 ad=0.079p as=0.079p pd=1.16u ps=1.16u nrd=1.15789 nrs=1.15789 sa=0.22u
+  sb=0.22u sd=0u
.ends dff

********************************************************************************
* Library          : dff
* Cell             : dff_test
* View             : schematic
* View Search List : schematic hspice symbol
* View Stop List   : symbol
********************************************************************************
xi0  dff
