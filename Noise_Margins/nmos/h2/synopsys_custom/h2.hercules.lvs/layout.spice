* SPICE INPUT		Tue Apr 21 21:39:08 2026	h2
* EV_NETLIST Version AMD.64 Release B-2008.09.SP5.26005 2012/07/14
*
*The following line needed for Star-CR:
*CRU_OPT (KEEP_ELEMENTS "^[CR]D")
*
*The following line needed for CDL:
*.BIPOLAR

* Top of hierarchy  cell=h2
.subckt h2 gnd! vdd! out
M_MM2 out vdd! net13 gnd! N  l=0.100u w=2.000u
M_MM1 net13 vdd! net12 gnd! N  l=0.100u w=2.000u
M_MM0 net12 vdd! vdd! gnd! N  l=0.100u w=2.000u
.ends h2
