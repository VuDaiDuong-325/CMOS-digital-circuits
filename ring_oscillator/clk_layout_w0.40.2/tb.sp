* =======================================================
* TESTBENCH SWEEP WN & Wp/Wn RATIO
* POST-LAYOUT RING OSCILLATOR
* =======================================================

.GLOBAL vdd! gnd!

* =======================================================
* PDK MODEL
* =======================================================

.include 'reference_models.inc'

* =======================================================
* POST-LAYOUT NETLIST
* =======================================================

.include '/root/Excercise/ring_oscillator/synopsys_custom/clk.starrc.lpe/clk.SPF'

* =======================================================
* PARAMETER
* =======================================================

.param WN    = 0.2u
.param RATIO = 2.25
.param WP    = 'WN*RATIO'

* =======================================================
* POWER SUPPLY
* =======================================================

V_vdd  vdd!  0  PWL(0s 0V 100ps 0V 300ps 1.2V)
V_gnd  gnd!  0  0V

* =======================================================
* DUT
* =======================================================

X_ring clk_out clk

* =======================================================
* FREQUENCY MEASUREMENT
* =======================================================

.meas tran t_rise_1 WHEN v(clk_out)=0.6 RISE=20
.meas tran t_rise_2 WHEN v(clk_out)=0.6 RISE=21

.meas tran freq_GHz PARAM='1/((t_rise_2-t_rise_1)*1e9)'

.meas tran wn_um     PARAM='WN*1e6'
.meas tran wp_um     PARAM='WP*1e6'
.meas tran ratio_out PARAM='RATIO'

* =======================================================
* TRANSIENT
* =======================================================

.tran 1p 5n SWEEP DATA=SIZE_SWEEP

* =======================================================
* SWEEP
* =======================================================

.DATA SIZE_SWEEP WN RATIO

0.1u 2.00
0.1u 2.25
0.1u 2.50
0.1u 2.75
0.1u 3.00

0.2u 2.00
0.2u 2.25
0.2u 2.50
0.2u 2.75
0.2u 3.00

0.3u 2.00
0.3u 2.25
0.3u 2.50
0.3u 2.75
0.3u 3.00

0.4u 2.00
0.4u 2.25
0.4u 2.50
0.4u 2.75
0.4u 3.00

0.5u 2.00
0.5u 2.25
0.5u 2.50
0.5u 2.75
0.5u 3.00

0.6u 2.00
0.6u 2.25
0.6u 2.50
0.6u 2.75
0.6u 3.00

0.7u 2.00
0.7u 2.25
0.7u 2.50
0.7u 2.75
0.7u 3.00

0.8u 2.00
0.8u 2.25
0.8u 2.50
0.8u 2.75
0.8u 3.00

0.9u 2.00
0.9u 2.25
0.9u 2.50
0.9u 2.75
0.9u 3.00

1.0u 2.00
1.0u 2.25
1.0u 2.50
1.0u 2.75
1.0u 3.00

.ENDDATA

* =======================================================
* OUTPUT
* =======================================================

.option post=2
.option measform=3
.option nomod

.probe tran v(clk_out)

.end
