* =======================================================
* TESTBENCH SWEEP LENGTH
* POST-LAYOUT RING OSCILLATOR
* =======================================================

.GLOBAL vdd! gnd!

* =======================================================
* PDK MODEL
* =======================================================

.include 'reference_models.inc'

* =======================================================
* POST-LAYOUT NETLIST
* =======================================================

.include '/root/Excercise/ring_oscillator/synopsys_custom/clk.starrc.lpe/clk.SPF'

* =======================================================
* PARAMETERS
* =======================================================

.param WN = 0.2u
.param WP = 0.4u
.param L  = 0.10u

* =======================================================
* POWER SUPPLY
* =======================================================

V_vdd vdd! 0 PWL(0s 0V 100ps 0V 300ps 1.2V)
V_gnd gnd! 0 0V

* =======================================================
* DUT
* =======================================================

X_ring clk_out clk

* =======================================================
* FREQUENCY MEASUREMENT
* =======================================================

.meas tran t_rise_1 WHEN v(clk_out)=0.6 RISE=20
.meas tran t_rise_2 WHEN v(clk_out)=0.6 RISE=21

.meas tran freq_GHz PARAM='1/((t_rise_2-t_rise_1)*1e9)'

.meas tran l_um  PARAM='L*1e6'
.meas tran wn_um PARAM='WN*1e6'
.meas tran wp_um PARAM='WP*1e6'

* =======================================================
* TRANSIENT
* =======================================================

.tran 1p 5n SWEEP DATA=L_SWEEP

* =======================================================
* SWEEP TABLE
* =======================================================

.DATA L_SWEEP WN WP L

0.2u 0.40u 0.10u
0.2u 0.40u 0.11u
0.2u 0.40u 0.12u
0.2u 0.40u 0.13u
0.2u 0.40u 0.14u
0.2u 0.40u 0.15u

0.2u 0.45u 0.10u
0.2u 0.45u 0.11u
0.2u 0.45u 0.12u
0.2u 0.45u 0.13u
0.2u 0.45u 0.14u
0.2u 0.45u 0.15u

0.2u 0.50u 0.10u
0.2u 0.50u 0.11u
0.2u 0.50u 0.12u
0.2u 0.50u 0.13u
0.2u 0.50u 0.14u
0.2u 0.50u 0.15u

0.2u 0.55u 0.10u
0.2u 0.55u 0.11u
0.2u 0.55u 0.12u
0.2u 0.55u 0.13u
0.2u 0.55u 0.14u
0.2u 0.55u 0.15u

0.2u 0.60u 0.10u
0.2u 0.60u 0.11u
0.2u 0.60u 0.12u
0.2u 0.60u 0.13u
0.2u 0.60u 0.14u
0.2u 0.60u 0.15u

.ENDDATA

* =======================================================
* OUTPUT
* =======================================================

.option post=2
.option measform=3
.option nomod

.probe tran v(clk_out)

.end
