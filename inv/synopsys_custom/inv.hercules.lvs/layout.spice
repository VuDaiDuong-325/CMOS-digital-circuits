* SPICE INPUT		Mon Jun  1 20:21:10 2026	inv
* EV_NETLIST Version AMD.64 Release B-2008.09.SP5.26005 2012/07/14
*
*The following line needed for Star-CR:
*CRU_OPT (KEEP_ELEMENTS "^[CR]D")
*
*The following line needed for CDL:
*.BIPOLAR

* Top of hierarchy  cell=inv
.subckt inv out vdd! gnd! in
M_MM3 gnd! in out ln_N_9 N  l=0.100u w=0.200u
M_MM2 vdd! in out ln_N_11 P  l=0.100u w=0.400u
.ends inv
